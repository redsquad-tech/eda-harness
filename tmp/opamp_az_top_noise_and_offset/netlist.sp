* `ngspice` Sim Input for `components.opamp_az_top.Tb`
* Generated by `vlsirtools.CompatibleNgspiceNetlister`
*
* Anonymous `circuit.Package`
* Generated by `vlsirtools.CompatibleNgspiceNetlister`
*

.SUBCKT TgSwitch_a388cb72e0c91c10eb34b4a0618eb2a1_
+ A B PHI PHIB VDD VSS
* No parameters

xsw_n
+ A PHI B VSS
+ sky130_fd_pr__nfet_01v8
+ w='0.65' l='0.15' nf='1' ad='int((nf+1)/2) * w/nf * 0.29' As='int((nf+2)/2) * w/nf * 0.29' pd='2*int((nf+1)/2) * (w/nf + 0.29)' ps='2*int((nf+2)/2) * (w/nf + 0.29)' nrd='0.29 / w' nrs='0.29 / w' sa='0' sb='0' sd='0' mult='1' m='1'

xsw_p
+ A PHIB B VDD
+ sky130_fd_pr__pfet_01v8
+ w='1' l='0.15' nf='1' ad='int((nf+1)/2) * w/nf * 0.29' As='int((nf+2)/2) * w/nf * 0.29' pd='2*int((nf+1)/2) * (w/nf + 0.29)' ps='2*int((nf+2)/2) * (w/nf + 0.29)' nrd='0.29 / w' nrs='0.29 / w' sa='0' sb='0' sd='0' mult='1' m='1'

.ENDS

.SUBCKT SampleHoldCap_e585a79b4806791f129c0489353e9787_
+ P N
* No parameters

xcap_0
+ P N
+ sky130_fd_pr__cap_mim_m3_1
+ w='3' l='3' mf='1'

.ENDS

.SUBCKT FrontendAz_3191280f186a38ed9542134367d2da54_
+ VINP VINN VXP VXN PHI1 PHI2 VDD VSS
* No parameters

rrvcm_top
+ VDD vcm
+ 3000000
* No parameters

rrvcm_bot
+ vcm VSS
+ 1000000
* No parameters

xxsw_samp_p
+ VINP samp_p PHI1 PHI2 VDD VSS
+ TgSwitch_a388cb72e0c91c10eb34b4a0618eb2a1_
* No parameters

xxsw_samp_n
+ VINN samp_n PHI1 PHI2 VDD VSS
+ TgSwitch_a388cb72e0c91c10eb34b4a0618eb2a1_
* No parameters

xxsw_reset_p
+ vcm VXP PHI1 PHI2 VDD VSS
+ TgSwitch_a388cb72e0c91c10eb34b4a0618eb2a1_
* No parameters

xxsw_reset_n
+ vcm VXN PHI1 PHI2 VDD VSS
+ TgSwitch_a388cb72e0c91c10eb34b4a0618eb2a1_
* No parameters

xxsw_rebias_p
+ samp_p vcm PHI2 PHI1 VDD VSS
+ TgSwitch_a388cb72e0c91c10eb34b4a0618eb2a1_
* No parameters

xxsw_rebias_n
+ samp_n vcm PHI2 PHI1 VDD VSS
+ TgSwitch_a388cb72e0c91c10eb34b4a0618eb2a1_
* No parameters

xxcap_p
+ samp_p VXP
+ SampleHoldCap_e585a79b4806791f129c0489353e9787_
* No parameters

xxcap_n
+ samp_n VXN
+ SampleHoldCap_e585a79b4806791f129c0489353e9787_
* No parameters

rrbleed_p
+ VXP vcm
+ 50000000
* No parameters

rrbleed_n
+ VXN vcm
+ 50000000
* No parameters

.ENDS

.SUBCKT BiasGen_64cfaf1eea1456c9c03bb1fbdcd87139_
+ VDD VSS EN IBIAS1 IBIAS2
* No parameters

rr_ref
+ iref VSS
+ 1800000.0000000002
* No parameters

xm_ref
+ iref iref VDD VDD
+ sky130_fd_pr__pfet_01v8
+ w='1' l='0.15' nf='1' ad='int((nf+1)/2) * w/nf * 0.29' As='int((nf+2)/2) * w/nf * 0.29' pd='2*int((nf+1)/2) * (w/nf + 0.29)' ps='2*int((nf+2)/2) * (w/nf + 0.29)' nrd='0.29 / w' nrs='0.29 / w' sa='0' sb='0' sd='0' mult='1' m='1'

xm_out1
+ IBIAS1 iref VDD VDD
+ sky130_fd_pr__pfet_01v8
+ w='1' l='0.15' nf='1' ad='int((nf+1)/2) * w/nf * 0.29' As='int((nf+2)/2) * w/nf * 0.29' pd='2*int((nf+1)/2) * (w/nf + 0.29)' ps='2*int((nf+2)/2) * (w/nf + 0.29)' nrd='0.29 / w' nrs='0.29 / w' sa='0' sb='0' sd='0' mult='1' m='1'

xm_out2
+ IBIAS2 iref VDD VDD
+ sky130_fd_pr__pfet_01v8
+ w='2' l='0.15' nf='1' ad='int((nf+1)/2) * w/nf * 0.29' As='int((nf+2)/2) * w/nf * 0.29' pd='2*int((nf+1)/2) * (w/nf + 0.29)' ps='2*int((nf+2)/2) * (w/nf + 0.29)' nrd='0.29 / w' nrs='0.29 / w' sa='0' sb='0' sd='0' mult='1' m='1'

ren_bleed
+ EN VSS
+ 1000000000
* No parameters

.ENDS

.SUBCKT DiffpairP_65f47a31780dac5f890de8b19b355bef_
+ INP INN OUTP OUTN TAIL VDD VSS
* No parameters

rshort_p
+ TAIL srcp
+ 0.001
* No parameters

rshort_n
+ TAIL srcn
+ 0.001
* No parameters

xmp
+ OUTP INP srcp VDD
+ sky130_fd_pr__pfet_01v8
+ w='1.5' l='2' nf='1' ad='int((nf+1)/2) * w/nf * 0.29' As='int((nf+2)/2) * w/nf * 0.29' pd='2*int((nf+1)/2) * (w/nf + 0.29)' ps='2*int((nf+2)/2) * (w/nf + 0.29)' nrd='0.29 / w' nrs='0.29 / w' sa='0' sb='0' sd='0' mult='1' m='1'

xmn
+ OUTN INN srcn VDD
+ sky130_fd_pr__pfet_01v8
+ w='1.5' l='2' nf='1' ad='int((nf+1)/2) * w/nf * 0.29' As='int((nf+2)/2) * w/nf * 0.29' pd='2*int((nf+1)/2) * (w/nf + 0.29)' ps='2*int((nf+2)/2) * (w/nf + 0.29)' nrd='0.29 / w' nrs='0.29 / w' sa='0' sb='0' sd='0' mult='1' m='1'

.ENDS

.SUBCKT GainStage_f794943be3f5a2f9aaba194e889e908d_
+ VINP VINN VX VREF IBIAS VDD VSS
* No parameters

xxin
+ VINP VINN VX VREF tail VDD VSS
+ DiffpairP_65f47a31780dac5f890de8b19b355bef_
* No parameters

xm_load_ref
+ VREF VREF VSS VSS
+ sky130_fd_pr__nfet_01v8
+ w='2' l='2' nf='1' ad='int((nf+1)/2) * w/nf * 0.29' As='int((nf+2)/2) * w/nf * 0.29' pd='2*int((nf+1)/2) * (w/nf + 0.29)' ps='2*int((nf+2)/2) * (w/nf + 0.29)' nrd='0.29 / w' nrs='0.29 / w' sa='0' sb='0' sd='0' mult='1' m='1'

xm_load_out
+ VX VREF VSS VSS
+ sky130_fd_pr__nfet_01v8
+ w='2' l='2' nf='1' ad='int((nf+1)/2) * w/nf * 0.29' As='int((nf+2)/2) * w/nf * 0.29' pd='2*int((nf+1)/2) * (w/nf + 0.29)' ps='2*int((nf+2)/2) * (w/nf + 0.29)' nrd='0.29 / w' nrs='0.29 / w' sa='0' sb='0' sd='0' mult='1' m='1'

ribias_short
+ IBIAS tail
+ 0.001
* No parameters

.ENDS

.SUBCKT SecondStage_6e3fcde278d5dba6851abcdeaf1406de_
+ VIN VOUT IBIAS VDD VSS
* No parameters

xm_load
+ VOUT IBIAS VSS VSS
+ sky130_fd_pr__nfet_01v8
+ w='0.400e1' l='4' nf='1' ad='int((nf+1)/2) * w/nf * 0.29' As='int((nf+2)/2) * w/nf * 0.29' pd='2*int((nf+1)/2) * (w/nf + 0.29)' ps='2*int((nf+2)/2) * (w/nf + 0.29)' nrd='0.29 / w' nrs='0.29 / w' sa='0' sb='0' sd='0' mult='1' m='1'

xm_amp
+ VOUT VIN VDD VDD
+ sky130_fd_pr__pfet_01v8
+ w='2' l='2' nf='1' ad='int((nf+1)/2) * w/nf * 0.29' As='int((nf+2)/2) * w/nf * 0.29' pd='2*int((nf+1)/2) * (w/nf + 0.29)' ps='2*int((nf+2)/2) * (w/nf + 0.29)' nrd='0.29 / w' nrs='0.29 / w' sa='0' sb='0' sd='0' mult='1' m='1'

ribias_probe
+ IBIAS VSS
+ 1000000000
* No parameters

.ENDS

.SUBCKT FreqComp_861586937c219552862fb4ee4997550e_
+ V1 VOUT
* No parameters

ccc
+ V1 VOUT
+ 4E-13
* No parameters

.ENDS

.SUBCKT OpampCore_671fc8b63ec64911aa17e59777829a4d_
+ VINP VINN VOUT EN VDD VSS
* No parameters

xxbias
+ VDD VSS EN ibias1 ibias2
+ BiasGen_64cfaf1eea1456c9c03bb1fbdcd87139_
* No parameters

xxgain
+ VINP VINN vx vref ibias1 VDD VSS
+ GainStage_f794943be3f5a2f9aaba194e889e908d_
* No parameters

rrvcm_top
+ VDD vcm
+ 10000000
* No parameters

rrvcm_bot
+ vcm VSS
+ 10000000
* No parameters

xbias2_ref
+ vbias2 vbias2 VSS VSS
+ sky130_fd_pr__nfet_01v8
+ w='2' l='2' nf='1' ad='int((nf+1)/2) * w/nf * 0.29' As='int((nf+2)/2) * w/nf * 0.29' pd='2*int((nf+1)/2) * (w/nf + 0.29)' ps='2*int((nf+2)/2) * (w/nf + 0.29)' nrd='0.29 / w' nrs='0.29 / w' sa='0' sb='0' sd='0' mult='1' m='1'

rbias2_short
+ ibias2 vbias2
+ 0.001
* No parameters

xxsecond
+ vx VOUT vbias2 VDD VSS
+ SecondStage_6e3fcde278d5dba6851abcdeaf1406de_
* No parameters

xxcomp
+ vx VOUT
+ FreqComp_861586937c219552862fb4ee4997550e_
* No parameters

rbleed_vx
+ vx vcm
+ 1000000000
* No parameters

rbleed_vref
+ vref vcm
+ 1000000000
* No parameters

rbleed_vout
+ VOUT vcm
+ 1000000000
* No parameters

.ENDS

.SUBCKT OpampAzTop_f223919da0db8bb073ca6ff854c476f5_
+ VINP VINN VOUT EN PHI1 PHI2 VDD VSS
* No parameters

xxfront
+ VINP VINN vxp vxn PHI1 PHI2 VDD VSS
+ FrontendAz_3191280f186a38ed9542134367d2da54_
* No parameters

xxcore
+ vxp vxn VOUT EN VDD VSS
+ OpampCore_671fc8b63ec64911aa17e59777829a4d_
* No parameters

.ENDS

.SUBCKT Tb
+ VSS
* No parameters

vvvdd
+ vdd_sig VSS
+ DC 1.8
* No parameters

vven
+ en VSS
+ DC 1.8
* No parameters

vvvinp
+ vinp VSS
+ DC 0
* No parameters

rrfb
+ vout vinn
+ 1
* No parameters

vvphi1
+ phi1 VSS
+ PULSE (0 1.8 0 2E-8 2E-8 8E-7 0.000002)
* No parameters

vvphi2
+ phi2 VSS
+ PULSE (0 1.8 0.000001 2E-8 2E-8 8E-7 0.000002)
* No parameters

ccload
+ vout VSS
+ 1E-12
* No parameters

rrload
+ vout VSS
+ 1000000
* No parameters

xxdut
+ vinp vinn vout en phi1 phi2 vdd_sig VSS
+ OpampAzTop_f223919da0db8bb073ca6ff854c476f5_
* No parameters

.ENDS

xtop 0 Tb // Top-Level DUT

.save time v(xtop.vout) v(xtop.phi2)
.lib "/home/vadim/work/eda-harness/pdks/sky130A/volare/sky130/versions/0fe599b2afb6708d281543108caf8310912f54af/sky130A/libs.tech/ngspice/sky130.lib.spice" tt
.tran 5e-08 8e-06
