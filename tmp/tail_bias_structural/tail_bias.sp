* Anonymous `circuit.Package`
* Generated by `vlsirtools.SpiceNetlister`
*

.SUBCKT TailBias_4e8a115daa6c5385ddd7d036efe51629_
+ BIAS OUT VDD VSS
* No parameters

xm_cas
+ OUT BIAS mid VSS
+ sky130_fd_pr__nfet_01v8
+ w='1' l='0.15' nf='1' ad='int((nf+1)/2) * w/nf * 0.29' As='int((nf+2)/2) * w/nf * 0.29' pd='2*int((nf+1)/2) * (w/nf + 0.29)' ps='2*int((nf+2)/2) * (w/nf + 0.29)' nrd='0.29 / w' nrs='0.29 / w' sa='0' sb='0' sd='0' mult='1' m='1'

xm_out
+ mid BIAS VSS VSS
+ sky130_fd_pr__nfet_01v8
+ w='1' l='0.15' nf='1' ad='int((nf+1)/2) * w/nf * 0.29' As='int((nf+2)/2) * w/nf * 0.29' pd='2*int((nf+1)/2) * (w/nf + 0.29)' ps='2*int((nf+2)/2) * (w/nf + 0.29)' nrd='0.29 / w' nrs='0.29 / w' sa='0' sb='0' sd='0' mult='1' m='1'

.ENDS
