* `ngspice` Sim Input for `components.opamp_core.Tb`
* Generated by `vlsirtools.CompatibleNgspiceNetlister`
*
* Anonymous `circuit.Package`
* Generated by `vlsirtools.CompatibleNgspiceNetlister`
*

.SUBCKT BiasGen_64cfaf1eea1456c9c03bb1fbdcd87139_
+ VDD VSS EN IBIAS1 IBIAS2
* No parameters

rr_ref
+ iref VSS
+ 1800000.0000000002
* No parameters

xm_ref
+ iref iref VDD VDD
+ sky130_fd_pr__pfet_01v8
+ w='1' l='0.15' nf='1' ad='int((nf+1)/2) * w/nf * 0.29' As='int((nf+2)/2) * w/nf * 0.29' pd='2*int((nf+1)/2) * (w/nf + 0.29)' ps='2*int((nf+2)/2) * (w/nf + 0.29)' nrd='0.29 / w' nrs='0.29 / w' sa='0' sb='0' sd='0' mult='1' m='1'

xm_out1
+ IBIAS1 iref VDD VDD
+ sky130_fd_pr__pfet_01v8
+ w='1' l='0.15' nf='1' ad='int((nf+1)/2) * w/nf * 0.29' As='int((nf+2)/2) * w/nf * 0.29' pd='2*int((nf+1)/2) * (w/nf + 0.29)' ps='2*int((nf+2)/2) * (w/nf + 0.29)' nrd='0.29 / w' nrs='0.29 / w' sa='0' sb='0' sd='0' mult='1' m='1'

xm_out2
+ IBIAS2 iref VDD VDD
+ sky130_fd_pr__pfet_01v8
+ w='2' l='0.15' nf='1' ad='int((nf+1)/2) * w/nf * 0.29' As='int((nf+2)/2) * w/nf * 0.29' pd='2*int((nf+1)/2) * (w/nf + 0.29)' ps='2*int((nf+2)/2) * (w/nf + 0.29)' nrd='0.29 / w' nrs='0.29 / w' sa='0' sb='0' sd='0' mult='1' m='1'

xm_disable
+ iref EN VDD VDD
+ sky130_fd_pr__pfet_01v8
+ w='1' l='0.15' nf='1' ad='int((nf+1)/2) * w/nf * 0.29' As='int((nf+2)/2) * w/nf * 0.29' pd='2*int((nf+1)/2) * (w/nf + 0.29)' ps='2*int((nf+2)/2) * (w/nf + 0.29)' nrd='0.29 / w' nrs='0.29 / w' sa='0' sb='0' sd='0' mult='1' m='1'

ren_bleed
+ EN VSS
+ 1000000000
* No parameters

.ENDS

.SUBCKT DiffpairP_65f47a31780dac5f890de8b19b355bef_
+ INP INN OUTP OUTN TAIL VDD VSS
* No parameters

rshort_p
+ TAIL srcp
+ 0.001
* No parameters

rshort_n
+ TAIL srcn
+ 0.001
* No parameters

xmp
+ OUTP INP srcp VDD
+ sky130_fd_pr__pfet_01v8
+ w='1.5' l='2' nf='1' ad='int((nf+1)/2) * w/nf * 0.29' As='int((nf+2)/2) * w/nf * 0.29' pd='2*int((nf+1)/2) * (w/nf + 0.29)' ps='2*int((nf+2)/2) * (w/nf + 0.29)' nrd='0.29 / w' nrs='0.29 / w' sa='0' sb='0' sd='0' mult='1' m='1'

xmn
+ OUTN INN srcn VDD
+ sky130_fd_pr__pfet_01v8
+ w='1.5' l='2' nf='1' ad='int((nf+1)/2) * w/nf * 0.29' As='int((nf+2)/2) * w/nf * 0.29' pd='2*int((nf+1)/2) * (w/nf + 0.29)' ps='2*int((nf+2)/2) * (w/nf + 0.29)' nrd='0.29 / w' nrs='0.29 / w' sa='0' sb='0' sd='0' mult='1' m='1'

.ENDS

.SUBCKT GainStage_f794943be3f5a2f9aaba194e889e908d_
+ VINP VINN VX VREF IBIAS VDD VSS
* No parameters

xxin
+ VINP VINN VX VREF tail VDD VSS
+ DiffpairP_65f47a31780dac5f890de8b19b355bef_
* No parameters

xm_load_ref
+ VREF VREF VSS VSS
+ sky130_fd_pr__nfet_01v8
+ w='2' l='2' nf='1' ad='int((nf+1)/2) * w/nf * 0.29' As='int((nf+2)/2) * w/nf * 0.29' pd='2*int((nf+1)/2) * (w/nf + 0.29)' ps='2*int((nf+2)/2) * (w/nf + 0.29)' nrd='0.29 / w' nrs='0.29 / w' sa='0' sb='0' sd='0' mult='1' m='1'

xm_load_out
+ VX VREF VSS VSS
+ sky130_fd_pr__nfet_01v8
+ w='2' l='2' nf='1' ad='int((nf+1)/2) * w/nf * 0.29' As='int((nf+2)/2) * w/nf * 0.29' pd='2*int((nf+1)/2) * (w/nf + 0.29)' ps='2*int((nf+2)/2) * (w/nf + 0.29)' nrd='0.29 / w' nrs='0.29 / w' sa='0' sb='0' sd='0' mult='1' m='1'

ribias_short
+ IBIAS tail
+ 0.001
* No parameters

.ENDS

.SUBCKT SecondStage_6e3fcde278d5dba6851abcdeaf1406de_
+ VIN VOUT IBIAS VDD VSS
* No parameters

xm_load
+ VOUT IBIAS VSS VSS
+ sky130_fd_pr__nfet_01v8
+ w='0.400e1' l='4' nf='1' ad='int((nf+1)/2) * w/nf * 0.29' As='int((nf+2)/2) * w/nf * 0.29' pd='2*int((nf+1)/2) * (w/nf + 0.29)' ps='2*int((nf+2)/2) * (w/nf + 0.29)' nrd='0.29 / w' nrs='0.29 / w' sa='0' sb='0' sd='0' mult='1' m='1'

xm_amp
+ VOUT VIN VDD VDD
+ sky130_fd_pr__pfet_01v8
+ w='2' l='2' nf='1' ad='int((nf+1)/2) * w/nf * 0.29' As='int((nf+2)/2) * w/nf * 0.29' pd='2*int((nf+1)/2) * (w/nf + 0.29)' ps='2*int((nf+2)/2) * (w/nf + 0.29)' nrd='0.29 / w' nrs='0.29 / w' sa='0' sb='0' sd='0' mult='1' m='1'

ribias_probe
+ IBIAS VSS
+ 1000000000
* No parameters

.ENDS

.SUBCKT OutputStage_aaaecd445ae0fc4d28337e19defc2b5c_
+ VIN VOUT IBIAS VDD VSS
* No parameters

xm_n
+ VSS VIN VOUT VSS
+ sky130_fd_pr__nfet_01v8
+ w='8' l='1' nf='1' ad='int((nf+1)/2) * w/nf * 0.29' As='int((nf+2)/2) * w/nf * 0.29' pd='2*int((nf+1)/2) * (w/nf + 0.29)' ps='2*int((nf+2)/2) * (w/nf + 0.29)' nrd='0.29 / w' nrs='0.29 / w' sa='0' sb='0' sd='0' mult='1' m='1'

xm_p
+ VDD VIN VOUT VDD
+ sky130_fd_pr__pfet_01v8
+ w='0.6400e2' l='1' nf='1' ad='int((nf+1)/2) * w/nf * 0.29' As='int((nf+2)/2) * w/nf * 0.29' pd='2*int((nf+1)/2) * (w/nf + 0.29)' ps='2*int((nf+2)/2) * (w/nf + 0.29)' nrd='0.29 / w' nrs='0.29 / w' sa='0' sb='0' sd='0' mult='1' m='1'

ribias_probe
+ IBIAS VSS
+ 1000000000
* No parameters

.ENDS

.SUBCKT FreqComp_861586937c219552862fb4ee4997550e_
+ V1 VOUT
* No parameters

ccc
+ V1 VOUT
+ 4E-13
* No parameters

.ENDS

.SUBCKT OpampCore_098d2537bba5687365cf79a91eaf1f9a_
+ VINP VINN VOUT EN VDD VSS
* No parameters

xxbias
+ VDD VSS EN ibias1 ibias2
+ BiasGen_64cfaf1eea1456c9c03bb1fbdcd87139_
* No parameters

xxgain
+ VINP VINN vx vref ibias1 VDD VSS
+ GainStage_f794943be3f5a2f9aaba194e889e908d_
* No parameters

rrvcm_top
+ VDD vcm
+ 10000000
* No parameters

rrvcm_bot
+ vcm VSS
+ 10000000
* No parameters

xbias2_ref
+ vbias2 vbias2 VSS VSS
+ sky130_fd_pr__nfet_01v8
+ w='2' l='2' nf='1' ad='int((nf+1)/2) * w/nf * 0.29' As='int((nf+2)/2) * w/nf * 0.29' pd='2*int((nf+1)/2) * (w/nf + 0.29)' ps='2*int((nf+2)/2) * (w/nf + 0.29)' nrd='0.29 / w' nrs='0.29 / w' sa='0' sb='0' sd='0' mult='1' m='1'

rbias2_short
+ ibias2 vbias2
+ 0.001
* No parameters

xxsecond
+ vx vdrv vbias2 VDD VSS
+ SecondStage_6e3fcde278d5dba6851abcdeaf1406de_
* No parameters

xxbuf
+ vdrv VOUT vcm VDD VSS
+ OutputStage_aaaecd445ae0fc4d28337e19defc2b5c_
* No parameters

xxcomp
+ vx vdrv
+ FreqComp_861586937c219552862fb4ee4997550e_
* No parameters

rbleed_vx
+ vx vcm
+ 1000000000
* No parameters

rbleed_vref
+ vref vcm
+ 1000000000
* No parameters

rbleed_vdrv
+ vdrv vcm
+ 1000000000
* No parameters

rbleed_vout
+ VOUT vcm
+ 1000000000
* No parameters

.ENDS

.SUBCKT Tb
+ VSS
* No parameters

vvvdd
+ vdd_sig VSS
+ DC 1.8
* No parameters

vven
+ en VSS
+ DC 1.8
* No parameters

vvvinp
+ vinp_sig VSS
+ DC 1.7
* No parameters

rrfb
+ vout vinn_sig
+ 1
* No parameters

ccload
+ vout VSS
+ 1E-12
* No parameters

rrload
+ vout VSS
+ 1000000000000
* No parameters

xxdut
+ vinp_sig vinn_sig vout en vdd_sig VSS
+ OpampCore_098d2537bba5687365cf79a91eaf1f9a_
* No parameters

.ENDS

xtop 0 Tb // Top-Level DUT

.save i(v.xtop.vvvdd) v(xtop.vout)
.temp 27.0
.lib "/home/vadim/work/eda-harness/pdks/sky130A/volare/sky130/versions/0fe599b2afb6708d281543108caf8310912f54af/sky130A/libs.tech/ngspice/sky130.lib.spice" tt
.op
