* `ngspice` Sim Input for `components.diffpair_n.Tb`
* Generated by `vlsirtools.CompatibleNgspiceNetlister`
*
* Anonymous `circuit.Package`
* Generated by `vlsirtools.CompatibleNgspiceNetlister`
*

.SUBCKT DiffpairN_c472ef1deef09a3f5716ae172250d805_
+ INP INN OUTP OUTN TAIL VDD VSS
* No parameters

rshort_p
+ srcp TAIL
+ 0.001
* No parameters

rshort_n
+ srcn TAIL
+ 0.001
* No parameters

xmp
+ OUTP INP srcp VSS
+ sky130_fd_pr__nfet_01v8
+ w='1' l='0.15' nf='1' ad='int((nf+1)/2) * w/nf * 0.29' As='int((nf+2)/2) * w/nf * 0.29' pd='2*int((nf+1)/2) * (w/nf + 0.29)' ps='2*int((nf+2)/2) * (w/nf + 0.29)' nrd='0.29 / w' nrs='0.29 / w' sa='0' sb='0' sd='0' mult='1' m='1'

xmn
+ OUTN INN srcn VSS
+ sky130_fd_pr__nfet_01v8
+ w='1' l='0.15' nf='1' ad='int((nf+1)/2) * w/nf * 0.29' As='int((nf+2)/2) * w/nf * 0.29' pd='2*int((nf+1)/2) * (w/nf + 0.29)' ps='2*int((nf+2)/2) * (w/nf + 0.29)' nrd='0.29 / w' nrs='0.29 / w' sa='0' sb='0' sd='0' mult='1' m='1'

.ENDS

.SUBCKT Tb
+ VSS
* No parameters

vvvdd
+ vdd VSS
+ DC 1.8
* No parameters

vvvinp
+ inp VSS
+ DC 0.9
* No parameters

vvvinn
+ inn VSS
+ DC 0.9
* No parameters

ii_tail
+ tail VSS
+ 0.0001
* No parameters

rrload_p
+ vdd outp
+ 20000
* No parameters

rrload_n
+ vdd outn
+ 20000
* No parameters

xxdut
+ inp inn outp outn tail vdd VSS
+ DiffpairN_c472ef1deef09a3f5716ae172250d805_
* No parameters

.ENDS

xtop 0 Tb // Top-Level DUT

.save all
.lib "/home/vadim/work/eda-harness/pdks/sky130A/volare/sky130/versions/0fe599b2afb6708d281543108caf8310912f54af/sky130A/libs.tech/ngspice/sky130.lib.spice" tt
.op
