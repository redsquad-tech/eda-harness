* Anonymous `circuit.Package`
* Generated by `vlsirtools.SpiceNetlister`
*

.SUBCKT SampleHoldCap_599661b439ea3c8f1f35c5873442cea2_
+ P N
* No parameters

xcap_0
+ P N
+ sky130_fd_pr__cap_mim_m3_1
+ w='3' l='3' mf='1'

.ENDS
