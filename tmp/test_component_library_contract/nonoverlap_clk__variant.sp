* Anonymous `circuit.Package`
* Generated by `vlsirtools.SpiceNetlister`
*

.SUBCKT NonoverlapInvClk
+ A Y VDD VSS
* No parameters

xn
+ Y A VSS VSS
+ sky130_fd_pr__nfet_01v8
+ w='0.65' l='0.15' nf='1' ad='int((nf+1)/2) * w/nf * 0.29' As='int((nf+2)/2) * w/nf * 0.29' pd='2*int((nf+1)/2) * (w/nf + 0.29)' ps='2*int((nf+2)/2) * (w/nf + 0.29)' nrd='0.29 / w' nrs='0.29 / w' sa='0' sb='0' sd='0' mult='1' m='1'

xp
+ Y A VDD VDD
+ sky130_fd_pr__pfet_01v8
+ w='1' l='0.15' nf='1' ad='int((nf+1)/2) * w/nf * 0.29' As='int((nf+2)/2) * w/nf * 0.29' pd='2*int((nf+1)/2) * (w/nf + 0.29)' ps='2*int((nf+2)/2) * (w/nf + 0.29)' nrd='0.29 / w' nrs='0.29 / w' sa='0' sb='0' sd='0' mult='1' m='1'

.ENDS

.SUBCKT ClkDelayInv_0
+ A Y VDD VSS
* No parameters

xn
+ Y A VSS VSS
+ sky130_fd_pr__nfet_01v8
+ w='0.65' l='0.15' nf='1' ad='int((nf+1)/2) * w/nf * 0.29' As='int((nf+2)/2) * w/nf * 0.29' pd='2*int((nf+1)/2) * (w/nf + 0.29)' ps='2*int((nf+2)/2) * (w/nf + 0.29)' nrd='0.29 / w' nrs='0.29 / w' sa='0' sb='0' sd='0' mult='1' m='1'

xp
+ Y A VDD VDD
+ sky130_fd_pr__pfet_01v8
+ w='1' l='0.15' nf='1' ad='int((nf+1)/2) * w/nf * 0.29' As='int((nf+2)/2) * w/nf * 0.29' pd='2*int((nf+1)/2) * (w/nf + 0.29)' ps='2*int((nf+2)/2) * (w/nf + 0.29)' nrd='0.29 / w' nrs='0.29 / w' sa='0' sb='0' sd='0' mult='1' m='1'

.ENDS

.SUBCKT ClkDelayInv_1
+ A Y VDD VSS
* No parameters

xn
+ Y A VSS VSS
+ sky130_fd_pr__nfet_01v8
+ w='0.9750000000000001' l='0.15' nf='1' ad='int((nf+1)/2) * w/nf * 0.29' As='int((nf+2)/2) * w/nf * 0.29' pd='2*int((nf+1)/2) * (w/nf + 0.29)' ps='2*int((nf+2)/2) * (w/nf + 0.29)' nrd='0.29 / w' nrs='0.29 / w' sa='0' sb='0' sd='0' mult='1' m='1'

xp
+ Y A VDD VDD
+ sky130_fd_pr__pfet_01v8
+ w='1.5' l='0.15' nf='1' ad='int((nf+1)/2) * w/nf * 0.29' As='int((nf+2)/2) * w/nf * 0.29' pd='2*int((nf+1)/2) * (w/nf + 0.29)' ps='2*int((nf+2)/2) * (w/nf + 0.29)' nrd='0.29 / w' nrs='0.29 / w' sa='0' sb='0' sd='0' mult='1' m='1'

.ENDS

.SUBCKT ClkDelayInv_2
+ A Y VDD VSS
* No parameters

xn
+ Y A VSS VSS
+ sky130_fd_pr__nfet_01v8
+ w='1.4625000000000001' l='0.15' nf='1' ad='int((nf+1)/2) * w/nf * 0.29' As='int((nf+2)/2) * w/nf * 0.29' pd='2*int((nf+1)/2) * (w/nf + 0.29)' ps='2*int((nf+2)/2) * (w/nf + 0.29)' nrd='0.29 / w' nrs='0.29 / w' sa='0' sb='0' sd='0' mult='1' m='1'

xp
+ Y A VDD VDD
+ sky130_fd_pr__pfet_01v8
+ w='2.25' l='0.15' nf='1' ad='int((nf+1)/2) * w/nf * 0.29' As='int((nf+2)/2) * w/nf * 0.29' pd='2*int((nf+1)/2) * (w/nf + 0.29)' ps='2*int((nf+2)/2) * (w/nf + 0.29)' nrd='0.29 / w' nrs='0.29 / w' sa='0' sb='0' sd='0' mult='1' m='1'

.ENDS

.SUBCKT ClkDelayInv_3
+ A Y VDD VSS
* No parameters

xn
+ Y A VSS VSS
+ sky130_fd_pr__nfet_01v8
+ w='2.19375' l='0.15' nf='1' ad='int((nf+1)/2) * w/nf * 0.29' As='int((nf+2)/2) * w/nf * 0.29' pd='2*int((nf+1)/2) * (w/nf + 0.29)' ps='2*int((nf+2)/2) * (w/nf + 0.29)' nrd='0.29 / w' nrs='0.29 / w' sa='0' sb='0' sd='0' mult='1' m='1'

xp
+ Y A VDD VDD
+ sky130_fd_pr__pfet_01v8
+ w='3.375' l='0.15' nf='1' ad='int((nf+1)/2) * w/nf * 0.29' As='int((nf+2)/2) * w/nf * 0.29' pd='2*int((nf+1)/2) * (w/nf + 0.29)' ps='2*int((nf+2)/2) * (w/nf + 0.29)' nrd='0.29 / w' nrs='0.29 / w' sa='0' sb='0' sd='0' mult='1' m='1'

.ENDS

.SUBCKT ClkDelayInv_4
+ A Y VDD VSS
* No parameters

xn
+ Y A VSS VSS
+ sky130_fd_pr__nfet_01v8
+ w='3.290625' l='0.15' nf='1' ad='int((nf+1)/2) * w/nf * 0.29' As='int((nf+2)/2) * w/nf * 0.29' pd='2*int((nf+1)/2) * (w/nf + 0.29)' ps='2*int((nf+2)/2) * (w/nf + 0.29)' nrd='0.29 / w' nrs='0.29 / w' sa='0' sb='0' sd='0' mult='1' m='1'

xp
+ Y A VDD VDD
+ sky130_fd_pr__pfet_01v8
+ w='5.0625' l='0.15' nf='1' ad='int((nf+1)/2) * w/nf * 0.29' As='int((nf+2)/2) * w/nf * 0.29' pd='2*int((nf+1)/2) * (w/nf + 0.29)' ps='2*int((nf+2)/2) * (w/nf + 0.29)' nrd='0.29 / w' nrs='0.29 / w' sa='0' sb='0' sd='0' mult='1' m='1'

.ENDS

.SUBCKT ClkDelayInv_5
+ A Y VDD VSS
* No parameters

xn
+ Y A VSS VSS
+ sky130_fd_pr__nfet_01v8
+ w='4.9359375000000005' l='0.15' nf='1' ad='int((nf+1)/2) * w/nf * 0.29' As='int((nf+2)/2) * w/nf * 0.29' pd='2*int((nf+1)/2) * (w/nf + 0.29)' ps='2*int((nf+2)/2) * (w/nf + 0.29)' nrd='0.29 / w' nrs='0.29 / w' sa='0' sb='0' sd='0' mult='1' m='1'

xp
+ Y A VDD VDD
+ sky130_fd_pr__pfet_01v8
+ w='7.59375' l='0.15' nf='1' ad='int((nf+1)/2) * w/nf * 0.29' As='int((nf+2)/2) * w/nf * 0.29' pd='2*int((nf+1)/2) * (w/nf + 0.29)' ps='2*int((nf+2)/2) * (w/nf + 0.29)' nrd='0.29 / w' nrs='0.29 / w' sa='0' sb='0' sd='0' mult='1' m='1'

.ENDS

.SUBCKT ClkbDelayInv_0
+ A Y VDD VSS
* No parameters

xn
+ Y A VSS VSS
+ sky130_fd_pr__nfet_01v8
+ w='0.65' l='0.15' nf='1' ad='int((nf+1)/2) * w/nf * 0.29' As='int((nf+2)/2) * w/nf * 0.29' pd='2*int((nf+1)/2) * (w/nf + 0.29)' ps='2*int((nf+2)/2) * (w/nf + 0.29)' nrd='0.29 / w' nrs='0.29 / w' sa='0' sb='0' sd='0' mult='1' m='1'

xp
+ Y A VDD VDD
+ sky130_fd_pr__pfet_01v8
+ w='1' l='0.15' nf='1' ad='int((nf+1)/2) * w/nf * 0.29' As='int((nf+2)/2) * w/nf * 0.29' pd='2*int((nf+1)/2) * (w/nf + 0.29)' ps='2*int((nf+2)/2) * (w/nf + 0.29)' nrd='0.29 / w' nrs='0.29 / w' sa='0' sb='0' sd='0' mult='1' m='1'

.ENDS

.SUBCKT ClkbDelayInv_1
+ A Y VDD VSS
* No parameters

xn
+ Y A VSS VSS
+ sky130_fd_pr__nfet_01v8
+ w='0.9750000000000001' l='0.15' nf='1' ad='int((nf+1)/2) * w/nf * 0.29' As='int((nf+2)/2) * w/nf * 0.29' pd='2*int((nf+1)/2) * (w/nf + 0.29)' ps='2*int((nf+2)/2) * (w/nf + 0.29)' nrd='0.29 / w' nrs='0.29 / w' sa='0' sb='0' sd='0' mult='1' m='1'

xp
+ Y A VDD VDD
+ sky130_fd_pr__pfet_01v8
+ w='1.5' l='0.15' nf='1' ad='int((nf+1)/2) * w/nf * 0.29' As='int((nf+2)/2) * w/nf * 0.29' pd='2*int((nf+1)/2) * (w/nf + 0.29)' ps='2*int((nf+2)/2) * (w/nf + 0.29)' nrd='0.29 / w' nrs='0.29 / w' sa='0' sb='0' sd='0' mult='1' m='1'

.ENDS

.SUBCKT ClkbDelayInv_2
+ A Y VDD VSS
* No parameters

xn
+ Y A VSS VSS
+ sky130_fd_pr__nfet_01v8
+ w='1.4625000000000001' l='0.15' nf='1' ad='int((nf+1)/2) * w/nf * 0.29' As='int((nf+2)/2) * w/nf * 0.29' pd='2*int((nf+1)/2) * (w/nf + 0.29)' ps='2*int((nf+2)/2) * (w/nf + 0.29)' nrd='0.29 / w' nrs='0.29 / w' sa='0' sb='0' sd='0' mult='1' m='1'

xp
+ Y A VDD VDD
+ sky130_fd_pr__pfet_01v8
+ w='2.25' l='0.15' nf='1' ad='int((nf+1)/2) * w/nf * 0.29' As='int((nf+2)/2) * w/nf * 0.29' pd='2*int((nf+1)/2) * (w/nf + 0.29)' ps='2*int((nf+2)/2) * (w/nf + 0.29)' nrd='0.29 / w' nrs='0.29 / w' sa='0' sb='0' sd='0' mult='1' m='1'

.ENDS

.SUBCKT ClkbDelayInv_3
+ A Y VDD VSS
* No parameters

xn
+ Y A VSS VSS
+ sky130_fd_pr__nfet_01v8
+ w='2.19375' l='0.15' nf='1' ad='int((nf+1)/2) * w/nf * 0.29' As='int((nf+2)/2) * w/nf * 0.29' pd='2*int((nf+1)/2) * (w/nf + 0.29)' ps='2*int((nf+2)/2) * (w/nf + 0.29)' nrd='0.29 / w' nrs='0.29 / w' sa='0' sb='0' sd='0' mult='1' m='1'

xp
+ Y A VDD VDD
+ sky130_fd_pr__pfet_01v8
+ w='3.375' l='0.15' nf='1' ad='int((nf+1)/2) * w/nf * 0.29' As='int((nf+2)/2) * w/nf * 0.29' pd='2*int((nf+1)/2) * (w/nf + 0.29)' ps='2*int((nf+2)/2) * (w/nf + 0.29)' nrd='0.29 / w' nrs='0.29 / w' sa='0' sb='0' sd='0' mult='1' m='1'

.ENDS

.SUBCKT ClkbDelayInv_4
+ A Y VDD VSS
* No parameters

xn
+ Y A VSS VSS
+ sky130_fd_pr__nfet_01v8
+ w='3.290625' l='0.15' nf='1' ad='int((nf+1)/2) * w/nf * 0.29' As='int((nf+2)/2) * w/nf * 0.29' pd='2*int((nf+1)/2) * (w/nf + 0.29)' ps='2*int((nf+2)/2) * (w/nf + 0.29)' nrd='0.29 / w' nrs='0.29 / w' sa='0' sb='0' sd='0' mult='1' m='1'

xp
+ Y A VDD VDD
+ sky130_fd_pr__pfet_01v8
+ w='5.0625' l='0.15' nf='1' ad='int((nf+1)/2) * w/nf * 0.29' As='int((nf+2)/2) * w/nf * 0.29' pd='2*int((nf+1)/2) * (w/nf + 0.29)' ps='2*int((nf+2)/2) * (w/nf + 0.29)' nrd='0.29 / w' nrs='0.29 / w' sa='0' sb='0' sd='0' mult='1' m='1'

.ENDS

.SUBCKT ClkbDelayInv_5
+ A Y VDD VSS
* No parameters

xn
+ Y A VSS VSS
+ sky130_fd_pr__nfet_01v8
+ w='4.9359375000000005' l='0.15' nf='1' ad='int((nf+1)/2) * w/nf * 0.29' As='int((nf+2)/2) * w/nf * 0.29' pd='2*int((nf+1)/2) * (w/nf + 0.29)' ps='2*int((nf+2)/2) * (w/nf + 0.29)' nrd='0.29 / w' nrs='0.29 / w' sa='0' sb='0' sd='0' mult='1' m='1'

xp
+ Y A VDD VDD
+ sky130_fd_pr__pfet_01v8
+ w='7.59375' l='0.15' nf='1' ad='int((nf+1)/2) * w/nf * 0.29' As='int((nf+2)/2) * w/nf * 0.29' pd='2*int((nf+1)/2) * (w/nf + 0.29)' ps='2*int((nf+2)/2) * (w/nf + 0.29)' nrd='0.29 / w' nrs='0.29 / w' sa='0' sb='0' sd='0' mult='1' m='1'

.ENDS

.SUBCKT NonoverlapInvOut
+ A Y VDD VSS
* No parameters

xn
+ Y A VSS VSS
+ sky130_fd_pr__nfet_01v8
+ w='0.65' l='0.15' nf='1' ad='int((nf+1)/2) * w/nf * 0.29' As='int((nf+2)/2) * w/nf * 0.29' pd='2*int((nf+1)/2) * (w/nf + 0.29)' ps='2*int((nf+2)/2) * (w/nf + 0.29)' nrd='0.29 / w' nrs='0.29 / w' sa='0' sb='0' sd='0' mult='1' m='1'

xp
+ Y A VDD VDD
+ sky130_fd_pr__pfet_01v8
+ w='1' l='0.15' nf='1' ad='int((nf+1)/2) * w/nf * 0.29' As='int((nf+2)/2) * w/nf * 0.29' pd='2*int((nf+1)/2) * (w/nf + 0.29)' ps='2*int((nf+2)/2) * (w/nf + 0.29)' nrd='0.29 / w' nrs='0.29 / w' sa='0' sb='0' sd='0' mult='1' m='1'

.ENDS

.SUBCKT NonoverlapAnd2_nand2
+ A B Y VDD VSS
* No parameters

xp0
+ Y A VDD VDD
+ sky130_fd_pr__pfet_01v8
+ w='1' l='0.15' nf='1' ad='int((nf+1)/2) * w/nf * 0.29' As='int((nf+2)/2) * w/nf * 0.29' pd='2*int((nf+1)/2) * (w/nf + 0.29)' ps='2*int((nf+2)/2) * (w/nf + 0.29)' nrd='0.29 / w' nrs='0.29 / w' sa='0' sb='0' sd='0' mult='1' m='1'

xp1
+ Y B VDD VDD
+ sky130_fd_pr__pfet_01v8
+ w='1' l='0.15' nf='1' ad='int((nf+1)/2) * w/nf * 0.29' As='int((nf+2)/2) * w/nf * 0.29' pd='2*int((nf+1)/2) * (w/nf + 0.29)' ps='2*int((nf+2)/2) * (w/nf + 0.29)' nrd='0.29 / w' nrs='0.29 / w' sa='0' sb='0' sd='0' mult='1' m='1'

xn0
+ Y A n_mid VSS
+ sky130_fd_pr__nfet_01v8
+ w='0.65' l='0.15' nf='1' ad='int((nf+1)/2) * w/nf * 0.29' As='int((nf+2)/2) * w/nf * 0.29' pd='2*int((nf+1)/2) * (w/nf + 0.29)' ps='2*int((nf+2)/2) * (w/nf + 0.29)' nrd='0.29 / w' nrs='0.29 / w' sa='0' sb='0' sd='0' mult='1' m='1'

xn1
+ n_mid B VSS VSS
+ sky130_fd_pr__nfet_01v8
+ w='0.65' l='0.15' nf='1' ad='int((nf+1)/2) * w/nf * 0.29' As='int((nf+2)/2) * w/nf * 0.29' pd='2*int((nf+1)/2) * (w/nf + 0.29)' ps='2*int((nf+2)/2) * (w/nf + 0.29)' nrd='0.29 / w' nrs='0.29 / w' sa='0' sb='0' sd='0' mult='1' m='1'

.ENDS

.SUBCKT NonoverlapAnd2_inv
+ A Y VDD VSS
* No parameters

xn
+ Y A VSS VSS
+ sky130_fd_pr__nfet_01v8
+ w='0.65' l='0.15' nf='1' ad='int((nf+1)/2) * w/nf * 0.29' As='int((nf+2)/2) * w/nf * 0.29' pd='2*int((nf+1)/2) * (w/nf + 0.29)' ps='2*int((nf+2)/2) * (w/nf + 0.29)' nrd='0.29 / w' nrs='0.29 / w' sa='0' sb='0' sd='0' mult='1' m='1'

xp
+ Y A VDD VDD
+ sky130_fd_pr__pfet_01v8
+ w='1' l='0.15' nf='1' ad='int((nf+1)/2) * w/nf * 0.29' As='int((nf+2)/2) * w/nf * 0.29' pd='2*int((nf+1)/2) * (w/nf + 0.29)' ps='2*int((nf+2)/2) * (w/nf + 0.29)' nrd='0.29 / w' nrs='0.29 / w' sa='0' sb='0' sd='0' mult='1' m='1'

.ENDS

.SUBCKT NonoverlapAnd2
+ A B Y VDD VSS
* No parameters

xnand
+ A B yb VDD VSS
+ NonoverlapAnd2_nand2
* No parameters

xbuf
+ yb Y VDD VSS
+ NonoverlapAnd2_inv
* No parameters

.ENDS

.SUBCKT NonoverlapClk_5068c465fe0945d2e23b11c0e94a98e2_
+ CLK_IN PHI1 PHI1B PHI2 PHI2B VDD VSS
* No parameters

xinv_clk
+ CLK_IN clkb VDD VSS
+ NonoverlapInvClk
* No parameters

xclk_delay_inv_0
+ CLK_IN clk_d_0 VDD VSS
+ ClkDelayInv_0
* No parameters

xclk_delay_inv_1
+ clk_d_0 clk_d_1 VDD VSS
+ ClkDelayInv_1
* No parameters

xclk_delay_inv_2
+ clk_d_1 clk_d_2 VDD VSS
+ ClkDelayInv_2
* No parameters

xclk_delay_inv_3
+ clk_d_2 clk_d_3 VDD VSS
+ ClkDelayInv_3
* No parameters

xclk_delay_inv_4
+ clk_d_3 clk_d_4 VDD VSS
+ ClkDelayInv_4
* No parameters

xclk_delay_inv_5
+ clk_d_4 clk_d VDD VSS
+ ClkDelayInv_5
* No parameters

xclkb_delay_inv_0
+ clkb clkb_d_0 VDD VSS
+ ClkbDelayInv_0
* No parameters

xclkb_delay_inv_1
+ clkb_d_0 clkb_d_1 VDD VSS
+ ClkbDelayInv_1
* No parameters

xclkb_delay_inv_2
+ clkb_d_1 clkb_d_2 VDD VSS
+ ClkbDelayInv_2
* No parameters

xclkb_delay_inv_3
+ clkb_d_2 clkb_d_3 VDD VSS
+ ClkbDelayInv_3
* No parameters

xclkb_delay_inv_4
+ clkb_d_3 clkb_d_4 VDD VSS
+ ClkbDelayInv_4
* No parameters

xclkb_delay_inv_5
+ clkb_d_4 clkb_d VDD VSS
+ ClkbDelayInv_5
* No parameters

xinv_clk_d
+ clk_d clk_d_b VDD VSS
+ NonoverlapInvOut
* No parameters

xinv_clkb_d
+ clkb_d clkb_d_b VDD VSS
+ NonoverlapInvOut
* No parameters

xgen_phi1
+ CLK_IN clkb_d_b PHI1 VDD VSS
+ NonoverlapAnd2
* No parameters

xgen_phi2
+ clkb clk_d_b PHI2 VDD VSS
+ NonoverlapAnd2
* No parameters

xgen_phi1b
+ PHI1 PHI1B VDD VSS
+ NonoverlapInvOut
* No parameters

xgen_phi2b
+ PHI2 PHI2B VDD VSS
+ NonoverlapInvOut
* No parameters

.ENDS
