* Anonymous `circuit.Package`
* Generated by `vlsirtools.SpiceNetlister`
*

.SUBCKT TgSwitch_a388cb72e0c91c10eb34b4a0618eb2a1_
+ A B PHI PHIB VDD VSS
* No parameters

xsw_n
+ A PHI B VSS
+ sky130_fd_pr__nfet_01v8
+ w='0.65' l='0.15' nf='1' ad='int((nf+1)/2) * w/nf * 0.29' As='int((nf+2)/2) * w/nf * 0.29' pd='2*int((nf+1)/2) * (w/nf + 0.29)' ps='2*int((nf+2)/2) * (w/nf + 0.29)' nrd='0.29 / w' nrs='0.29 / w' sa='0' sb='0' sd='0' mult='1' m='1'

xsw_p
+ A PHIB B VDD
+ sky130_fd_pr__pfet_01v8
+ w='1' l='0.15' nf='1' ad='int((nf+1)/2) * w/nf * 0.29' As='int((nf+2)/2) * w/nf * 0.29' pd='2*int((nf+1)/2) * (w/nf + 0.29)' ps='2*int((nf+2)/2) * (w/nf + 0.29)' nrd='0.29 / w' nrs='0.29 / w' sa='0' sb='0' sd='0' mult='1' m='1'

.ENDS

.SUBCKT SampleHoldCap_e585a79b4806791f129c0489353e9787_
+ P N
* No parameters

xcap_0
+ P N
+ sky130_fd_pr__cap_mim_m3_1
+ w='3' l='3' mf='1'

.ENDS

.SUBCKT FrontendAz_68703c833643f66cb25235cfa14faa3d_
+ VINP VINN VXP VXN PHI1 PHI2 VDD VSS
* No parameters

xxsw_inp
+ VINP samp_p PHI1 PHI2 VDD VSS
+ TgSwitch_a388cb72e0c91c10eb34b4a0618eb2a1_
* No parameters

xxsw_inn
+ VINN samp_n PHI1 PHI2 VDD VSS
+ TgSwitch_a388cb72e0c91c10eb34b4a0618eb2a1_
* No parameters

xxsw_amp_p
+ samp_p VXP PHI2 PHI1 VDD VSS
+ TgSwitch_a388cb72e0c91c10eb34b4a0618eb2a1_
* No parameters

xxsw_amp_n
+ samp_n VXN PHI2 PHI1 VDD VSS
+ TgSwitch_a388cb72e0c91c10eb34b4a0618eb2a1_
* No parameters

xxcap_p
+ samp_p VSS
+ SampleHoldCap_e585a79b4806791f129c0489353e9787_
* No parameters

xxcap_n
+ samp_n VSS
+ SampleHoldCap_e585a79b4806791f129c0489353e9787_
* No parameters

.ENDS
