* Anonymous `circuit.Package`
* Generated by `vlsirtools.SpiceNetlister`
*

.SUBCKT FreqComp_6a14f77ab1f7285608cf68e1752959d4_
+ V1 VOUT
* No parameters

ccc
+ V1 VOUT
+ 2E-13
* No parameters

.ENDS
