* `ngspice` Sim Input for `components.tail_bias.Tb`
* Generated by `vlsirtools.CompatibleNgspiceNetlister`
*
* Anonymous `circuit.Package`
* Generated by `vlsirtools.CompatibleNgspiceNetlister`
*

.SUBCKT TailBias_4e8a115daa6c5385ddd7d036efe51629_
+ BIAS OUT VDD VSS
* No parameters

xm_cas
+ OUT BIAS mid VSS
+ sky130_fd_pr__nfet_01v8
+ w='1' l='0.15' nf='1' ad='int((nf+1)/2) * w/nf * 0.29' As='int((nf+2)/2) * w/nf * 0.29' pd='2*int((nf+1)/2) * (w/nf + 0.29)' ps='2*int((nf+2)/2) * (w/nf + 0.29)' nrd='0.29 / w' nrs='0.29 / w' sa='0' sb='0' sd='0' mult='1' m='1'

xm_out
+ mid BIAS VSS VSS
+ sky130_fd_pr__nfet_01v8
+ w='1' l='0.15' nf='1' ad='int((nf+1)/2) * w/nf * 0.29' As='int((nf+2)/2) * w/nf * 0.29' pd='2*int((nf+1)/2) * (w/nf + 0.29)' ps='2*int((nf+2)/2) * (w/nf + 0.29)' nrd='0.29 / w' nrs='0.29 / w' sa='0' sb='0' sd='0' mult='1' m='1'

.ENDS

.SUBCKT Tb
+ VSS
* No parameters

vvvdd
+ vdd VSS
+ DC 1.8
* No parameters

vvbias
+ bias VSS
+ DC 0.75
* No parameters

rrload
+ vdd out
+ 20000
* No parameters

xxdut
+ bias out vdd VSS
+ TailBias_4e8a115daa6c5385ddd7d036efe51629_
* No parameters

.ENDS

xtop 0 Tb // Top-Level DUT

.save all
.lib "/home/vadim/work/eda-harness/pdks/sky130A/volare/sky130/versions/0fe599b2afb6708d281543108caf8310912f54af/sky130A/libs.tech/ngspice/sky130.lib.spice" tt
.op
