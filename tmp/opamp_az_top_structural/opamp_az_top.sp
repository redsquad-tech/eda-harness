* Anonymous `circuit.Package`
* Generated by `vlsirtools.SpiceNetlister`
*

.SUBCKT TgSwitch_a388cb72e0c91c10eb34b4a0618eb2a1_
+ A B PHI PHIB VDD VSS
* No parameters

xsw_n
+ A PHI B VSS
+ sky130_fd_pr__nfet_01v8
+ w='0.65' l='0.15' nf='1' ad='int((nf+1)/2) * w/nf * 0.29' As='int((nf+2)/2) * w/nf * 0.29' pd='2*int((nf+1)/2) * (w/nf + 0.29)' ps='2*int((nf+2)/2) * (w/nf + 0.29)' nrd='0.29 / w' nrs='0.29 / w' sa='0' sb='0' sd='0' mult='1' m='1'

xsw_p
+ A PHIB B VDD
+ sky130_fd_pr__pfet_01v8
+ w='1' l='0.15' nf='1' ad='int((nf+1)/2) * w/nf * 0.29' As='int((nf+2)/2) * w/nf * 0.29' pd='2*int((nf+1)/2) * (w/nf + 0.29)' ps='2*int((nf+2)/2) * (w/nf + 0.29)' nrd='0.29 / w' nrs='0.29 / w' sa='0' sb='0' sd='0' mult='1' m='1'

.ENDS

.SUBCKT SampleHoldCap_e585a79b4806791f129c0489353e9787_
+ P N
* No parameters

xcap_0
+ P N
+ sky130_fd_pr__cap_mim_m3_1
+ w='3' l='3' mf='1'

.ENDS

.SUBCKT FrontendAz_68703c833643f66cb25235cfa14faa3d_
+ VINP VINN VXP VXN PHI1 PHI2 VDD VSS
* No parameters

xxsw_inp
+ VINP samp_p PHI1 PHI2 VDD VSS
+ TgSwitch_a388cb72e0c91c10eb34b4a0618eb2a1_
* No parameters

xxsw_inn
+ VINN samp_n PHI1 PHI2 VDD VSS
+ TgSwitch_a388cb72e0c91c10eb34b4a0618eb2a1_
* No parameters

xxsw_amp_p
+ samp_p VXP PHI2 PHI1 VDD VSS
+ TgSwitch_a388cb72e0c91c10eb34b4a0618eb2a1_
* No parameters

xxsw_amp_n
+ samp_n VXN PHI2 PHI1 VDD VSS
+ TgSwitch_a388cb72e0c91c10eb34b4a0618eb2a1_
* No parameters

xxcap_p
+ samp_p VSS
+ SampleHoldCap_e585a79b4806791f129c0489353e9787_
* No parameters

xxcap_n
+ samp_n VSS
+ SampleHoldCap_e585a79b4806791f129c0489353e9787_
* No parameters

.ENDS

.SUBCKT BiasGen_64cfaf1eea1456c9c03bb1fbdcd87139_
+ VDD VSS EN IBIAS1 IBIAS2
* No parameters

rr_ref
+ iref VSS
+ 1800000.0000000002
* No parameters

xm_ref
+ iref iref VDD VDD
+ sky130_fd_pr__pfet_01v8
+ w='1' l='0.15' nf='1' ad='int((nf+1)/2) * w/nf * 0.29' As='int((nf+2)/2) * w/nf * 0.29' pd='2*int((nf+1)/2) * (w/nf + 0.29)' ps='2*int((nf+2)/2) * (w/nf + 0.29)' nrd='0.29 / w' nrs='0.29 / w' sa='0' sb='0' sd='0' mult='1' m='1'

xm_out1
+ IBIAS1 iref VDD VDD
+ sky130_fd_pr__pfet_01v8
+ w='1' l='0.15' nf='1' ad='int((nf+1)/2) * w/nf * 0.29' As='int((nf+2)/2) * w/nf * 0.29' pd='2*int((nf+1)/2) * (w/nf + 0.29)' ps='2*int((nf+2)/2) * (w/nf + 0.29)' nrd='0.29 / w' nrs='0.29 / w' sa='0' sb='0' sd='0' mult='1' m='1'

xm_out2
+ IBIAS2 iref VDD VDD
+ sky130_fd_pr__pfet_01v8
+ w='2' l='0.15' nf='1' ad='int((nf+1)/2) * w/nf * 0.29' As='int((nf+2)/2) * w/nf * 0.29' pd='2*int((nf+1)/2) * (w/nf + 0.29)' ps='2*int((nf+2)/2) * (w/nf + 0.29)' nrd='0.29 / w' nrs='0.29 / w' sa='0' sb='0' sd='0' mult='1' m='1'

ren_bleed
+ EN VSS
+ 1000000000
* No parameters

.ENDS

.SUBCKT DiffpairP_1d368c40de6037db360a85596ba31a3c_
+ INP INN OUTP OUTN TAIL VDD VSS
* No parameters

rshort_p
+ TAIL srcp
+ 0.001
* No parameters

rshort_n
+ TAIL srcn
+ 0.001
* No parameters

xmp
+ OUTP INP srcp VDD
+ sky130_fd_pr__pfet_01v8
+ w='1' l='0.15' nf='1' ad='int((nf+1)/2) * w/nf * 0.29' As='int((nf+2)/2) * w/nf * 0.29' pd='2*int((nf+1)/2) * (w/nf + 0.29)' ps='2*int((nf+2)/2) * (w/nf + 0.29)' nrd='0.29 / w' nrs='0.29 / w' sa='0' sb='0' sd='0' mult='1' m='1'

xmn
+ OUTN INN srcn VDD
+ sky130_fd_pr__pfet_01v8
+ w='1' l='0.15' nf='1' ad='int((nf+1)/2) * w/nf * 0.29' As='int((nf+2)/2) * w/nf * 0.29' pd='2*int((nf+1)/2) * (w/nf + 0.29)' ps='2*int((nf+2)/2) * (w/nf + 0.29)' nrd='0.29 / w' nrs='0.29 / w' sa='0' sb='0' sd='0' mult='1' m='1'

.ENDS

.SUBCKT ActiveLoad_954d8d6243f66d39f066819f2af7c943_
+ INP INN OUTP OUTN VDD VSS
* No parameters

xm_ref_p
+ INP INP VSS VSS
+ sky130_fd_pr__nfet_01v8
+ w='1' l='0.15' nf='1' ad='int((nf+1)/2) * w/nf * 0.29' As='int((nf+2)/2) * w/nf * 0.29' pd='2*int((nf+1)/2) * (w/nf + 0.29)' ps='2*int((nf+2)/2) * (w/nf + 0.29)' nrd='0.29 / w' nrs='0.29 / w' sa='0' sb='0' sd='0' mult='1' m='1'

xm_ref_n
+ INN INN VSS VSS
+ sky130_fd_pr__nfet_01v8
+ w='1' l='0.15' nf='1' ad='int((nf+1)/2) * w/nf * 0.29' As='int((nf+2)/2) * w/nf * 0.29' pd='2*int((nf+1)/2) * (w/nf + 0.29)' ps='2*int((nf+2)/2) * (w/nf + 0.29)' nrd='0.29 / w' nrs='0.29 / w' sa='0' sb='0' sd='0' mult='1' m='1'

xm_out_p
+ OUTP INP VSS VSS
+ sky130_fd_pr__nfet_01v8
+ w='1' l='0.15' nf='1' ad='int((nf+1)/2) * w/nf * 0.29' As='int((nf+2)/2) * w/nf * 0.29' pd='2*int((nf+1)/2) * (w/nf + 0.29)' ps='2*int((nf+2)/2) * (w/nf + 0.29)' nrd='0.29 / w' nrs='0.29 / w' sa='0' sb='0' sd='0' mult='1' m='1'

xm_out_n
+ OUTN INN VSS VSS
+ sky130_fd_pr__nfet_01v8
+ w='1' l='0.15' nf='1' ad='int((nf+1)/2) * w/nf * 0.29' As='int((nf+2)/2) * w/nf * 0.29' pd='2*int((nf+1)/2) * (w/nf + 0.29)' ps='2*int((nf+2)/2) * (w/nf + 0.29)' nrd='0.29 / w' nrs='0.29 / w' sa='0' sb='0' sd='0' mult='1' m='1'

.ENDS

.SUBCKT GainStage_6151c5b9c0e1c2efb840fbc7b5ee8127_
+ VINP VINN OUTP OUTN IBIAS VDD VSS
* No parameters

xxin
+ VINP VINN OUTP OUTN tail VDD VSS
+ DiffpairP_1d368c40de6037db360a85596ba31a3c_
* No parameters

xxload
+ OUTP OUTN OUTP OUTN VDD VSS
+ ActiveLoad_954d8d6243f66d39f066819f2af7c943_
* No parameters

ribias_short
+ IBIAS tail
+ 0.001
* No parameters

.ENDS

.SUBCKT SecondStage_79c48f09a135e58efc6c6e19a9f76d1d_
+ VIN VOUT IBIAS VDD VSS
* No parameters

xm_amp
+ VOUT VIN VSS VSS
+ sky130_fd_pr__nfet_01v8
+ w='1' l='0.15' nf='1' ad='int((nf+1)/2) * w/nf * 0.29' As='int((nf+2)/2) * w/nf * 0.29' pd='2*int((nf+1)/2) * (w/nf + 0.29)' ps='2*int((nf+2)/2) * (w/nf + 0.29)' nrd='0.29 / w' nrs='0.29 / w' sa='0' sb='0' sd='0' mult='1' m='1'

rr_load
+ VDD VOUT
+ 100000
* No parameters

ribias_probe
+ IBIAS VSS
+ 1000000
* No parameters

.ENDS

.SUBCKT FreqComp_6a14f77ab1f7285608cf68e1752959d4_
+ V1 VOUT
* No parameters

ccc
+ V1 VOUT
+ 2E-13
* No parameters

.ENDS

.SUBCKT OpampCore_d798f92d042fd5cdae1c7e96e160c0dc_
+ VINP VINN VOUT EN VDD VSS
* No parameters

xxbias
+ VDD VSS EN ibias1 ibias2
+ BiasGen_64cfaf1eea1456c9c03bb1fbdcd87139_
* No parameters

xxgain
+ VINP VINN outp outn ibias1 VDD VSS
+ GainStage_6151c5b9c0e1c2efb840fbc7b5ee8127_
* No parameters

xxsecond
+ outp VOUT ibias2 VDD VSS
+ SecondStage_79c48f09a135e58efc6c6e19a9f76d1d_
* No parameters

xxcomp
+ outp VOUT
+ FreqComp_6a14f77ab1f7285608cf68e1752959d4_
* No parameters

rbleed_outn
+ outn VSS
+ 1000000
* No parameters

.ENDS

.SUBCKT OpampAzTop_f82d600ef145555433294f1d1c7c48a7_
+ VINP VINN VOUT EN PHI1 PHI2 VDD VSS
* No parameters

xxfront
+ VINP VINN vxp vxn PHI1 PHI2 VDD VSS
+ FrontendAz_68703c833643f66cb25235cfa14faa3d_
* No parameters

xxcore
+ vxp vxn VOUT EN VDD VSS
+ OpampCore_d798f92d042fd5cdae1c7e96e160c0dc_
* No parameters

.ENDS
