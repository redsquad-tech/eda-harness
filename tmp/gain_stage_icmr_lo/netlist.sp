* `ngspice` Sim Input for `components.gain_stage.Tb`
* Generated by `vlsirtools.CompatibleNgspiceNetlister`
*
* Anonymous `circuit.Package`
* Generated by `vlsirtools.CompatibleNgspiceNetlister`
*

.SUBCKT DiffpairP_65f47a31780dac5f890de8b19b355bef_
+ INP INN OUTP OUTN TAIL VDD VSS
* No parameters

rshort_p
+ TAIL srcp
+ 0.001
* No parameters

rshort_n
+ TAIL srcn
+ 0.001
* No parameters

xmp
+ OUTP INP srcp VDD
+ sky130_fd_pr__pfet_01v8
+ w='1.5' l='2' nf='1' ad='int((nf+1)/2) * w/nf * 0.29' As='int((nf+2)/2) * w/nf * 0.29' pd='2*int((nf+1)/2) * (w/nf + 0.29)' ps='2*int((nf+2)/2) * (w/nf + 0.29)' nrd='0.29 / w' nrs='0.29 / w' sa='0' sb='0' sd='0' mult='1' m='1'

xmn
+ OUTN INN srcn VDD
+ sky130_fd_pr__pfet_01v8
+ w='1.5' l='2' nf='1' ad='int((nf+1)/2) * w/nf * 0.29' As='int((nf+2)/2) * w/nf * 0.29' pd='2*int((nf+1)/2) * (w/nf + 0.29)' ps='2*int((nf+2)/2) * (w/nf + 0.29)' nrd='0.29 / w' nrs='0.29 / w' sa='0' sb='0' sd='0' mult='1' m='1'

.ENDS

.SUBCKT GainStage_258d311016ab7dc4dbee6d0560dccae1_
+ VINP VINN VX VREF IBIAS VDD VSS
* No parameters

xxin
+ VINP VINN VX VREF tail VDD VSS
+ DiffpairP_65f47a31780dac5f890de8b19b355bef_
* No parameters

xm_ref_cas
+ VREF VREF ref_mid VSS
+ sky130_fd_pr__nfet_01v8
+ w='2' l='2' nf='1' ad='int((nf+1)/2) * w/nf * 0.29' As='int((nf+2)/2) * w/nf * 0.29' pd='2*int((nf+1)/2) * (w/nf + 0.29)' ps='2*int((nf+2)/2) * (w/nf + 0.29)' nrd='0.29 / w' nrs='0.29 / w' sa='0' sb='0' sd='0' mult='1' m='1'

xm_ref_bot
+ ref_mid ref_mid VSS VSS
+ sky130_fd_pr__nfet_01v8
+ w='2' l='2' nf='1' ad='int((nf+1)/2) * w/nf * 0.29' As='int((nf+2)/2) * w/nf * 0.29' pd='2*int((nf+1)/2) * (w/nf + 0.29)' ps='2*int((nf+2)/2) * (w/nf + 0.29)' nrd='0.29 / w' nrs='0.29 / w' sa='0' sb='0' sd='0' mult='1' m='1'

xm_out_cas
+ VX VREF out_mid VSS
+ sky130_fd_pr__nfet_01v8
+ w='2' l='2' nf='1' ad='int((nf+1)/2) * w/nf * 0.29' As='int((nf+2)/2) * w/nf * 0.29' pd='2*int((nf+1)/2) * (w/nf + 0.29)' ps='2*int((nf+2)/2) * (w/nf + 0.29)' nrd='0.29 / w' nrs='0.29 / w' sa='0' sb='0' sd='0' mult='1' m='1'

xm_out_bot
+ out_mid ref_mid VSS VSS
+ sky130_fd_pr__nfet_01v8
+ w='2' l='2' nf='1' ad='int((nf+1)/2) * w/nf * 0.29' As='int((nf+2)/2) * w/nf * 0.29' pd='2*int((nf+1)/2) * (w/nf + 0.29)' ps='2*int((nf+2)/2) * (w/nf + 0.29)' nrd='0.29 / w' nrs='0.29 / w' sa='0' sb='0' sd='0' mult='1' m='1'

ribias_short
+ IBIAS tail
+ 0.001
* No parameters

.ENDS

.SUBCKT Tb
+ VSS
* No parameters

vvvdd
+ vdd_sig VSS
+ DC 1.8
* No parameters

vvvinp
+ vinp_sig VSS
+ DC 0
* No parameters

vvvinn
+ vinn_sig VSS
+ DC 0
* No parameters

iibias_src
+ vdd_sig ibias
+ 0.000001
* No parameters

rrprobe_vx
+ vx VSS
+ 1000000
* No parameters

rrprobe_vref
+ vref VSS
+ 1000000
* No parameters

xxdut
+ vinp_sig vinn_sig vx vref ibias vdd_sig VSS
+ GainStage_258d311016ab7dc4dbee6d0560dccae1_
* No parameters

.ENDS

xtop 0 Tb // Top-Level DUT

.save all
.lib "/home/vadim/work/eda-harness/pdks/sky130A/volare/sky130/versions/0fe599b2afb6708d281543108caf8310912f54af/sky130A/libs.tech/ngspice/sky130.lib.spice" tt
.op
