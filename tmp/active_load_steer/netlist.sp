* `ngspice` Sim Input for `components.active_load.Tb`
* Generated by `vlsirtools.CompatibleNgspiceNetlister`
*
* Anonymous `circuit.Package`
* Generated by `vlsirtools.CompatibleNgspiceNetlister`
*

.SUBCKT ActiveLoad_0286dfff34ee860a860872c515ed92f3_
+ INP INN OUTP OUTN VDD VSS
* No parameters

xm_ref_p
+ INP INP VDD VDD
+ sky130_fd_pr__pfet_01v8
+ w='1' l='0.15' nf='1' ad='int((nf+1)/2) * w/nf * 0.29' As='int((nf+2)/2) * w/nf * 0.29' pd='2*int((nf+1)/2) * (w/nf + 0.29)' ps='2*int((nf+2)/2) * (w/nf + 0.29)' nrd='0.29 / w' nrs='0.29 / w' sa='0' sb='0' sd='0' mult='1' m='1'

xm_ref_n
+ INN INN VDD VDD
+ sky130_fd_pr__pfet_01v8
+ w='1' l='0.15' nf='1' ad='int((nf+1)/2) * w/nf * 0.29' As='int((nf+2)/2) * w/nf * 0.29' pd='2*int((nf+1)/2) * (w/nf + 0.29)' ps='2*int((nf+2)/2) * (w/nf + 0.29)' nrd='0.29 / w' nrs='0.29 / w' sa='0' sb='0' sd='0' mult='1' m='1'

xm_out_p
+ OUTP INP VDD VDD
+ sky130_fd_pr__pfet_01v8
+ w='1' l='0.15' nf='1' ad='int((nf+1)/2) * w/nf * 0.29' As='int((nf+2)/2) * w/nf * 0.29' pd='2*int((nf+1)/2) * (w/nf + 0.29)' ps='2*int((nf+2)/2) * (w/nf + 0.29)' nrd='0.29 / w' nrs='0.29 / w' sa='0' sb='0' sd='0' mult='1' m='1'

xm_out_n
+ OUTN INN VDD VDD
+ sky130_fd_pr__pfet_01v8
+ w='1' l='0.15' nf='1' ad='int((nf+1)/2) * w/nf * 0.29' As='int((nf+2)/2) * w/nf * 0.29' pd='2*int((nf+1)/2) * (w/nf + 0.29)' ps='2*int((nf+2)/2) * (w/nf + 0.29)' nrd='0.29 / w' nrs='0.29 / w' sa='0' sb='0' sd='0' mult='1' m='1'

.ENDS

.SUBCKT Tb
+ VSS
* No parameters

vvvdd
+ vdd VSS
+ DC 1.8
* No parameters

xxdut
+ inp inn outp outn vdd VSS
+ ActiveLoad_0286dfff34ee860a860872c515ed92f3_
* No parameters

iiref_p
+ inp VSS
+ 0.00003
* No parameters

iiref_n
+ inn VSS
+ 0.00001
* No parameters

rrload_p
+ outp VSS
+ 20000
* No parameters

rrload_n
+ outn VSS
+ 20000
* No parameters

.ENDS

xtop 0 Tb // Top-Level DUT

.save all
.lib "/home/vadim/work/eda-harness/pdks/sky130A/volare/sky130/versions/0fe599b2afb6708d281543108caf8310912f54af/sky130A/libs.tech/ngspice/sky130.lib.spice" tt
.op
