* `ngspice` Sim Input for `components.frontend_az.Tb`
* Generated by `vlsirtools.CompatibleNgspiceNetlister`
*
* Anonymous `circuit.Package`
* Generated by `vlsirtools.CompatibleNgspiceNetlister`
*

.SUBCKT TgSwitch_a388cb72e0c91c10eb34b4a0618eb2a1_
+ A B PHI PHIB VDD VSS
* No parameters

xsw_n
+ A PHI B VSS
+ sky130_fd_pr__nfet_01v8
+ w='0.65' l='0.15' nf='1' ad='int((nf+1)/2) * w/nf * 0.29' As='int((nf+2)/2) * w/nf * 0.29' pd='2*int((nf+1)/2) * (w/nf + 0.29)' ps='2*int((nf+2)/2) * (w/nf + 0.29)' nrd='0.29 / w' nrs='0.29 / w' sa='0' sb='0' sd='0' mult='1' m='1'

xsw_p
+ A PHIB B VDD
+ sky130_fd_pr__pfet_01v8
+ w='1' l='0.15' nf='1' ad='int((nf+1)/2) * w/nf * 0.29' As='int((nf+2)/2) * w/nf * 0.29' pd='2*int((nf+1)/2) * (w/nf + 0.29)' ps='2*int((nf+2)/2) * (w/nf + 0.29)' nrd='0.29 / w' nrs='0.29 / w' sa='0' sb='0' sd='0' mult='1' m='1'

.ENDS

.SUBCKT SampleHoldCap_e585a79b4806791f129c0489353e9787_
+ P N
* No parameters

xcap_0
+ P N
+ sky130_fd_pr__cap_mim_m3_1
+ w='3' l='3' mf='1'

.ENDS

.SUBCKT FrontendAz_68703c833643f66cb25235cfa14faa3d_
+ VINP VINN VXP VXN PHI1 PHI2 VDD VSS
* No parameters

xxsw_inp
+ VINP samp_p PHI1 PHI2 VDD VSS
+ TgSwitch_a388cb72e0c91c10eb34b4a0618eb2a1_
* No parameters

xxsw_inn
+ VINN samp_n PHI1 PHI2 VDD VSS
+ TgSwitch_a388cb72e0c91c10eb34b4a0618eb2a1_
* No parameters

xxsw_amp_p
+ samp_p VXP PHI2 PHI1 VDD VSS
+ TgSwitch_a388cb72e0c91c10eb34b4a0618eb2a1_
* No parameters

xxsw_amp_n
+ samp_n VXN PHI2 PHI1 VDD VSS
+ TgSwitch_a388cb72e0c91c10eb34b4a0618eb2a1_
* No parameters

xxcap_p
+ samp_p VSS
+ SampleHoldCap_e585a79b4806791f129c0489353e9787_
* No parameters

xxcap_n
+ samp_n VSS
+ SampleHoldCap_e585a79b4806791f129c0489353e9787_
* No parameters

.ENDS

.SUBCKT Tb
+ VSS
* No parameters

vvvdd
+ vdd_sig VSS
+ DC 1.8
* No parameters

vvvinp
+ vinp VSS
+ PULSE (0 0 0.000002 5E-8 5E-8 0.000008 0.000016)
* No parameters

vvvinn
+ vinn VSS
+ DC 0
* No parameters

vvphi1
+ phi1 VSS
+ PULSE (0 1.8 0 2E-8 2E-8 8E-7 0.000002)
* No parameters

vvphi2
+ phi2 VSS
+ PULSE (0 1.8 0.000001 2E-8 2E-8 8E-7 0.000002)
* No parameters

ccload_p
+ vxp VSS
+ 2E-13
* No parameters

ccload_n
+ vxn VSS
+ 2E-13
* No parameters

rrbleed_p
+ vxp VSS
+ 1000000
* No parameters

rrbleed_n
+ vxn VSS
+ 1000000
* No parameters

xxdut
+ vinp vinn vxp vxn phi1 phi2 vdd_sig VSS
+ FrontendAz_68703c833643f66cb25235cfa14faa3d_
* No parameters

.ENDS

xtop 0 Tb // Top-Level DUT

.save all
.lib "/home/vadim/work/eda-harness/pdks/sky130A/volare/sky130/versions/0fe599b2afb6708d281543108caf8310912f54af/sky130A/libs.tech/ngspice/sky130.lib.spice" tt
.include "/home/vadim/work/eda-harness/pdks/sky130A/volare/sky130/versions/0fe599b2afb6708d281543108caf8310912f54af/sky130A/libs.tech/ngspice/corners/tt.spice"
.include "/home/vadim/work/eda-harness/pdks/sky130A/volare/sky130/versions/0fe599b2afb6708d281543108caf8310912f54af/sky130A/libs.tech/ngspice/r+c/res_typical__cap_typical.spice"
.include "/home/vadim/work/eda-harness/pdks/sky130A/volare/sky130/versions/0fe599b2afb6708d281543108caf8310912f54af/sky130A/libs.tech/ngspice/r+c/res_typical__cap_typical__lin.spice"
.include "/home/vadim/work/eda-harness/pdks/sky130A/volare/sky130/versions/0fe599b2afb6708d281543108caf8310912f54af/sky130A/libs.tech/ngspice/corners/tt/specialized_cells.spice"
.tran 2e-08 8e-06
