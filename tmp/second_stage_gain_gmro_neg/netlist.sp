* `ngspice` Sim Input for `components.second_stage.Tb`
* Generated by `vlsirtools.CompatibleNgspiceNetlister`
*
* Anonymous `circuit.Package`
* Generated by `vlsirtools.CompatibleNgspiceNetlister`
*

.SUBCKT SecondStage_5204c14d8fe39f26c8ff7fc5594f4f62_
+ VIN VOUT IBIAS VDD VSS
* No parameters

xm_load
+ VOUT IBIAS VSS VSS
+ sky130_fd_pr__nfet_01v8
+ w='0.600e1' l='2' nf='1' ad='int((nf+1)/2) * w/nf * 0.29' As='int((nf+2)/2) * w/nf * 0.29' pd='2*int((nf+1)/2) * (w/nf + 0.29)' ps='2*int((nf+2)/2) * (w/nf + 0.29)' nrd='0.29 / w' nrs='0.29 / w' sa='0' sb='0' sd='0' mult='1' m='1'

xm_amp
+ VOUT VIN VDD VDD
+ sky130_fd_pr__pfet_01v8
+ w='2' l='2' nf='1' ad='int((nf+1)/2) * w/nf * 0.29' As='int((nf+2)/2) * w/nf * 0.29' pd='2*int((nf+1)/2) * (w/nf + 0.29)' ps='2*int((nf+2)/2) * (w/nf + 0.29)' nrd='0.29 / w' nrs='0.29 / w' sa='0' sb='0' sd='0' mult='1' m='1'

ribias_probe
+ IBIAS VSS
+ 1000000000
* No parameters

.ENDS

.SUBCKT Tb
+ VSS
* No parameters

vvvdd
+ vdd_sig VSS
+ DC 1.8
* No parameters

vvvin
+ vin_sig VSS
+ DC 0.595
* No parameters

vvbias
+ ibias VSS
+ DC 0.75
* No parameters

xxdut
+ vin_sig vout ibias vdd_sig VSS
+ SecondStage_5204c14d8fe39f26c8ff7fc5594f4f62_
* No parameters

rrload
+ vout VSS
+ 1000000000000
* No parameters

.ENDS

xtop 0 Tb // Top-Level DUT

.option method = gear

.option itl1 = 500

.save v(xtop.vout) v(xtop.vdd_sig) v(xtop.vin_sig) v(xtop.ibias) i(v.xtop.vvvdd)
.lib "/home/vadim/work/eda-harness/pdks/sky130A/volare/sky130/versions/0fe599b2afb6708d281543108caf8310912f54af/sky130A/libs.tech/ngspice/sky130.lib.spice" tt
.op
