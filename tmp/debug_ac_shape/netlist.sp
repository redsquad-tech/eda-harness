* `ngspice` Sim Input for `components.freq_comp.Tb`
* Generated by `vlsirtools.CompatibleNgspiceNetlister`
*
* Anonymous `circuit.Package`
* Generated by `vlsirtools.CompatibleNgspiceNetlister`
*

.SUBCKT FreqComp_6a14f77ab1f7285608cf68e1752959d4_
+ V1 VOUT
* No parameters

ccc
+ V1 VOUT
+ 2E-13
* No parameters

.ENDS

.SUBCKT Tb
+ VSS
* No parameters

vvac
+ v1 VSS
+ DC 0
+ AC 1
* No parameters

rrload
+ vout VSS
+ 1000000
* No parameters

xxdut
+ v1 vout
+ FreqComp_6a14f77ab1f7285608cf68e1752959d4_
* No parameters

.ENDS

xtop 0 Tb // Top-Level DUT

.save all
.ac dec 10 1000.0 1000000000.0
