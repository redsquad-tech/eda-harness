* Anonymous `circuit.Package`
* Generated by `vlsirtools.SpiceNetlister`
*

.SUBCKT CascodeBlock_780c6378d19d044e5b052f1084207ebe_
+ IN OUT BCAS VDD VSS
* No parameters

xm_cas
+ OUT BCAS mid VDD
+ sky130_fd_pr__pfet_01v8
+ w='1' l='0.15' nf='1' ad='int((nf+1)/2) * w/nf * 0.29' As='int((nf+2)/2) * w/nf * 0.29' pd='2*int((nf+1)/2) * (w/nf + 0.29)' ps='2*int((nf+2)/2) * (w/nf + 0.29)' nrd='0.29 / w' nrs='0.29 / w' sa='0' sb='0' sd='0' mult='1' m='1'

xm_main
+ mid IN IN VDD
+ sky130_fd_pr__pfet_01v8
+ w='1' l='0.15' nf='1' ad='int((nf+1)/2) * w/nf * 0.29' As='int((nf+2)/2) * w/nf * 0.29' pd='2*int((nf+1)/2) * (w/nf + 0.29)' ps='2*int((nf+2)/2) * (w/nf + 0.29)' nrd='0.29 / w' nrs='0.29 / w' sa='0' sb='0' sd='0' mult='1' m='1'

.ENDS
