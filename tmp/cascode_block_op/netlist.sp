* `ngspice` Sim Input for `components.cascode_block.Tb`
* Generated by `vlsirtools.CompatibleNgspiceNetlister`
*
* Anonymous `circuit.Package`
* Generated by `vlsirtools.CompatibleNgspiceNetlister`
*

.SUBCKT CascodeBlock_5abf917fdd52a19621cb66e9e3395380_
+ IN OUT BCAS VDD VSS
* No parameters

xm_cas
+ OUT BCAS mid VSS
+ sky130_fd_pr__nfet_01v8
+ w='1' l='0.15' nf='1' ad='int((nf+1)/2) * w/nf * 0.29' As='int((nf+2)/2) * w/nf * 0.29' pd='2*int((nf+1)/2) * (w/nf + 0.29)' ps='2*int((nf+2)/2) * (w/nf + 0.29)' nrd='0.29 / w' nrs='0.29 / w' sa='0' sb='0' sd='0' mult='1' m='1'

xm_main
+ mid IN IN VSS
+ sky130_fd_pr__nfet_01v8
+ w='1' l='0.15' nf='1' ad='int((nf+1)/2) * w/nf * 0.29' As='int((nf+2)/2) * w/nf * 0.29' pd='2*int((nf+1)/2) * (w/nf + 0.29)' ps='2*int((nf+2)/2) * (w/nf + 0.29)' nrd='0.29 / w' nrs='0.29 / w' sa='0' sb='0' sd='0' mult='1' m='1'

.ENDS

.SUBCKT Tb
+ VSS
* No parameters

vvvdd
+ vdd VSS
+ DC 1.8
* No parameters

vvin
+ inn VSS
+ DC 0.5
* No parameters

vvbcas
+ bcas VSS
+ DC 0.9
* No parameters

xxdut
+ inn out bcas vdd VSS
+ CascodeBlock_5abf917fdd52a19621cb66e9e3395380_
* No parameters

rrload
+ vdd out
+ 20000
* No parameters

.ENDS

xtop 0 Tb // Top-Level DUT

.save all
.lib "/home/vadim/work/eda-harness/pdks/sky130A/volare/sky130/versions/0fe599b2afb6708d281543108caf8310912f54af/sky130A/libs.tech/ngspice/sky130.lib.spice" tt
.op
