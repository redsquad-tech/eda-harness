* Anonymous `circuit.Package`
* Generated by `vlsirtools.SpiceNetlister`
*

.SUBCKT DiffpairP_1d368c40de6037db360a85596ba31a3c_
+ INP INN OUTP OUTN TAIL VDD VSS
* No parameters

rshort_p
+ TAIL srcp
+ 0.001
* No parameters

rshort_n
+ TAIL srcn
+ 0.001
* No parameters

xmp
+ OUTP INP srcp VDD
+ sky130_fd_pr__pfet_01v8
+ w='1' l='0.15' nf='1' ad='int((nf+1)/2) * w/nf * 0.29' As='int((nf+2)/2) * w/nf * 0.29' pd='2*int((nf+1)/2) * (w/nf + 0.29)' ps='2*int((nf+2)/2) * (w/nf + 0.29)' nrd='0.29 / w' nrs='0.29 / w' sa='0' sb='0' sd='0' mult='1' m='1'

xmn
+ OUTN INN srcn VDD
+ sky130_fd_pr__pfet_01v8
+ w='1' l='0.15' nf='1' ad='int((nf+1)/2) * w/nf * 0.29' As='int((nf+2)/2) * w/nf * 0.29' pd='2*int((nf+1)/2) * (w/nf + 0.29)' ps='2*int((nf+2)/2) * (w/nf + 0.29)' nrd='0.29 / w' nrs='0.29 / w' sa='0' sb='0' sd='0' mult='1' m='1'

.ENDS

.SUBCKT ActiveLoad_954d8d6243f66d39f066819f2af7c943_
+ INP INN OUTP OUTN VDD VSS
* No parameters

xm_ref_p
+ INP INP VSS VSS
+ sky130_fd_pr__nfet_01v8
+ w='1' l='0.15' nf='1' ad='int((nf+1)/2) * w/nf * 0.29' As='int((nf+2)/2) * w/nf * 0.29' pd='2*int((nf+1)/2) * (w/nf + 0.29)' ps='2*int((nf+2)/2) * (w/nf + 0.29)' nrd='0.29 / w' nrs='0.29 / w' sa='0' sb='0' sd='0' mult='1' m='1'

xm_ref_n
+ INN INN VSS VSS
+ sky130_fd_pr__nfet_01v8
+ w='1' l='0.15' nf='1' ad='int((nf+1)/2) * w/nf * 0.29' As='int((nf+2)/2) * w/nf * 0.29' pd='2*int((nf+1)/2) * (w/nf + 0.29)' ps='2*int((nf+2)/2) * (w/nf + 0.29)' nrd='0.29 / w' nrs='0.29 / w' sa='0' sb='0' sd='0' mult='1' m='1'

xm_out_p
+ OUTP INP VSS VSS
+ sky130_fd_pr__nfet_01v8
+ w='1' l='0.15' nf='1' ad='int((nf+1)/2) * w/nf * 0.29' As='int((nf+2)/2) * w/nf * 0.29' pd='2*int((nf+1)/2) * (w/nf + 0.29)' ps='2*int((nf+2)/2) * (w/nf + 0.29)' nrd='0.29 / w' nrs='0.29 / w' sa='0' sb='0' sd='0' mult='1' m='1'

xm_out_n
+ OUTN INN VSS VSS
+ sky130_fd_pr__nfet_01v8
+ w='1' l='0.15' nf='1' ad='int((nf+1)/2) * w/nf * 0.29' As='int((nf+2)/2) * w/nf * 0.29' pd='2*int((nf+1)/2) * (w/nf + 0.29)' ps='2*int((nf+2)/2) * (w/nf + 0.29)' nrd='0.29 / w' nrs='0.29 / w' sa='0' sb='0' sd='0' mult='1' m='1'

.ENDS

.SUBCKT GainStage_6151c5b9c0e1c2efb840fbc7b5ee8127_
+ VINP VINN OUTP OUTN IBIAS VDD VSS
* No parameters

xxin
+ VINP VINN OUTP OUTN tail VDD VSS
+ DiffpairP_1d368c40de6037db360a85596ba31a3c_
* No parameters

xxload
+ OUTP OUTN OUTP OUTN VDD VSS
+ ActiveLoad_954d8d6243f66d39f066819f2af7c943_
* No parameters

ribias_probe
+ IBIAS tail
+ 1000
* No parameters

.ENDS
