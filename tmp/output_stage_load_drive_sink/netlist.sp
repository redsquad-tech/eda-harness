* `ngspice` Sim Input for `components.output_stage.Tb`
* Generated by `vlsirtools.CompatibleNgspiceNetlister`
*
* Anonymous `circuit.Package`
* Generated by `vlsirtools.CompatibleNgspiceNetlister`
*

.SUBCKT OutputStage_496dd3c23a42aee35c31a330199bf32a_
+ VIN VOUT IBIAS VDD VSS
* No parameters

xm_p
+ VOUT VIN VDD VDD
+ sky130_fd_pr__pfet_01v8
+ w='1.200e1' l='1' nf='1' ad='int((nf+1)/2) * w/nf * 0.29' As='int((nf+2)/2) * w/nf * 0.29' pd='2*int((nf+1)/2) * (w/nf + 0.29)' ps='2*int((nf+2)/2) * (w/nf + 0.29)' nrd='0.29 / w' nrs='0.29 / w' sa='0' sb='0' sd='0' mult='1' m='1'

xm_n
+ VOUT VIN VSS VSS
+ sky130_fd_pr__nfet_01v8
+ w='4' l='1' nf='1' ad='int((nf+1)/2) * w/nf * 0.29' As='int((nf+2)/2) * w/nf * 0.29' pd='2*int((nf+1)/2) * (w/nf + 0.29)' ps='2*int((nf+2)/2) * (w/nf + 0.29)' nrd='0.29 / w' nrs='0.29 / w' sa='0' sb='0' sd='0' mult='1' m='1'

ribias_probe
+ IBIAS VSS
+ 1000000000
* No parameters

.ENDS

.SUBCKT Tb
+ VSS
* No parameters

vvvdd
+ vdd_sig VSS
+ DC 1.8
* No parameters

vvvin
+ vin_sig VSS
+ DC 1.8
* No parameters

vvbias
+ ibias VSS
+ DC 0.75
* No parameters

xxdut
+ vin_sig vout ibias vdd_sig VSS
+ OutputStage_496dd3c23a42aee35c31a330199bf32a_
* No parameters

rrload
+ vdd_sig vout
+ 100000
* No parameters

.ENDS

xtop 0 Tb // Top-Level DUT

.option method = gear

.option itl1 = 500

.save v(xtop.vout) v(xtop.vdd_sig) v(xtop.vin_sig) v(xtop.ibias) i(v.xtop.vvvdd)
.lib "/home/vadim/work/eda-harness/pdks/sky130A/volare/sky130/versions/0fe599b2afb6708d281543108caf8310912f54af/sky130A/libs.tech/ngspice/sky130.lib.spice" tt
.op
