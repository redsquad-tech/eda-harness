* Anonymous `circuit.Package`
* Generated by `vlsirtools.SpiceNetlister`
*

.SUBCKT SampleHoldCap_0e404de129e1c774436ee0a6b1c6c012_
+ P N
* No parameters

xcap_0
+ P nser_0
+ sky130_fd_pr__cap_mim_m3_1
+ w='3' l='3' mf='1'

xcap_1
+ nser_0 nser_1
+ sky130_fd_pr__cap_mim_m3_1
+ w='3' l='3' mf='1'

xcap_2
+ nser_1 N
+ sky130_fd_pr__cap_mim_m3_1
+ w='3' l='3' mf='1'

.ENDS
