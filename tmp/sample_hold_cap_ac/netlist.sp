* `ngspice` Sim Input for `components.sample_hold_cap.Tb`
* Generated by `vlsirtools.CompatibleNgspiceNetlister`
*
* Anonymous `circuit.Package`
* Generated by `vlsirtools.CompatibleNgspiceNetlister`
*

.SUBCKT SampleHoldCap_599661b439ea3c8f1f35c5873442cea2_
+ P N
* No parameters

xcap_0
+ P N
+ sky130_fd_pr__cap_mim_m3_1
+ w='3' l='3' mf='1'

.ENDS

.SUBCKT Tb
+ VSS
* No parameters

vvac
+ p VSS
+ DC 0
+ AC 1
* No parameters

xxdut
+ p VSS
+ SampleHoldCap_599661b439ea3c8f1f35c5873442cea2_
* No parameters

.ENDS

xtop 0 Tb // Top-Level DUT

.save all
.param mc_mm_switch=0
.param mc_pr_switch=0
.include "/home/vadim/work/eda-harness/pdks/sky130A/volare/sky130/versions/0fe599b2afb6708d281543108caf8310912f54af/sky130A/libs.tech/ngspice/corners/tt.spice"
.include "/home/vadim/work/eda-harness/pdks/sky130A/volare/sky130/versions/0fe599b2afb6708d281543108caf8310912f54af/sky130A/libs.tech/ngspice/r+c/res_typical__cap_typical.spice"
.include "/home/vadim/work/eda-harness/pdks/sky130A/volare/sky130/versions/0fe599b2afb6708d281543108caf8310912f54af/sky130A/libs.tech/ngspice/r+c/res_typical__cap_typical__lin.spice"
.include "/home/vadim/work/eda-harness/pdks/sky130A/volare/sky130/versions/0fe599b2afb6708d281543108caf8310912f54af/sky130A/libs.tech/ngspice/corners/tt/specialized_cells.spice"
.ac dec 5 1000.0 1000000.0
