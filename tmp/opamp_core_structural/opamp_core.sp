* Anonymous `circuit.Package`
* Generated by `vlsirtools.SpiceNetlister`
*

.SUBCKT BiasGen_64cfaf1eea1456c9c03bb1fbdcd87139_
+ VDD VSS EN IBIAS1 IBIAS2
* No parameters

rr_ref
+ iref VSS
+ 1800000.0000000002
* No parameters

xm_ref
+ iref iref VDD VDD
+ sky130_fd_pr__pfet_01v8
+ w='1' l='0.15' nf='1' ad='int((nf+1)/2) * w/nf * 0.29' As='int((nf+2)/2) * w/nf * 0.29' pd='2*int((nf+1)/2) * (w/nf + 0.29)' ps='2*int((nf+2)/2) * (w/nf + 0.29)' nrd='0.29 / w' nrs='0.29 / w' sa='0' sb='0' sd='0' mult='1' m='1'

xm_out1
+ IBIAS1 iref VDD VDD
+ sky130_fd_pr__pfet_01v8
+ w='1' l='0.15' nf='1' ad='int((nf+1)/2) * w/nf * 0.29' As='int((nf+2)/2) * w/nf * 0.29' pd='2*int((nf+1)/2) * (w/nf + 0.29)' ps='2*int((nf+2)/2) * (w/nf + 0.29)' nrd='0.29 / w' nrs='0.29 / w' sa='0' sb='0' sd='0' mult='1' m='1'

xm_out2
+ IBIAS2 iref VDD VDD
+ sky130_fd_pr__pfet_01v8
+ w='2' l='0.15' nf='1' ad='int((nf+1)/2) * w/nf * 0.29' As='int((nf+2)/2) * w/nf * 0.29' pd='2*int((nf+1)/2) * (w/nf + 0.29)' ps='2*int((nf+2)/2) * (w/nf + 0.29)' nrd='0.29 / w' nrs='0.29 / w' sa='0' sb='0' sd='0' mult='1' m='1'

ren_bleed
+ EN VSS
+ 1000000000
* No parameters

.ENDS

.SUBCKT DiffpairP_65f47a31780dac5f890de8b19b355bef_
+ INP INN OUTP OUTN TAIL VDD VSS
* No parameters

rshort_p
+ TAIL srcp
+ 0.001
* No parameters

rshort_n
+ TAIL srcn
+ 0.001
* No parameters

xmp
+ OUTP INP srcp VDD
+ sky130_fd_pr__pfet_01v8
+ w='1.5' l='2' nf='1' ad='int((nf+1)/2) * w/nf * 0.29' As='int((nf+2)/2) * w/nf * 0.29' pd='2*int((nf+1)/2) * (w/nf + 0.29)' ps='2*int((nf+2)/2) * (w/nf + 0.29)' nrd='0.29 / w' nrs='0.29 / w' sa='0' sb='0' sd='0' mult='1' m='1'

xmn
+ OUTN INN srcn VDD
+ sky130_fd_pr__pfet_01v8
+ w='1.5' l='2' nf='1' ad='int((nf+1)/2) * w/nf * 0.29' As='int((nf+2)/2) * w/nf * 0.29' pd='2*int((nf+1)/2) * (w/nf + 0.29)' ps='2*int((nf+2)/2) * (w/nf + 0.29)' nrd='0.29 / w' nrs='0.29 / w' sa='0' sb='0' sd='0' mult='1' m='1'

.ENDS

.SUBCKT GainStage_f794943be3f5a2f9aaba194e889e908d_
+ VINP VINN VX VREF IBIAS VDD VSS
* No parameters

xxin
+ VINP VINN VX VREF tail VDD VSS
+ DiffpairP_65f47a31780dac5f890de8b19b355bef_
* No parameters

xm_load_ref
+ VREF VREF VSS VSS
+ sky130_fd_pr__nfet_01v8
+ w='2' l='2' nf='1' ad='int((nf+1)/2) * w/nf * 0.29' As='int((nf+2)/2) * w/nf * 0.29' pd='2*int((nf+1)/2) * (w/nf + 0.29)' ps='2*int((nf+2)/2) * (w/nf + 0.29)' nrd='0.29 / w' nrs='0.29 / w' sa='0' sb='0' sd='0' mult='1' m='1'

xm_load_out
+ VX VREF VSS VSS
+ sky130_fd_pr__nfet_01v8
+ w='2' l='2' nf='1' ad='int((nf+1)/2) * w/nf * 0.29' As='int((nf+2)/2) * w/nf * 0.29' pd='2*int((nf+1)/2) * (w/nf + 0.29)' ps='2*int((nf+2)/2) * (w/nf + 0.29)' nrd='0.29 / w' nrs='0.29 / w' sa='0' sb='0' sd='0' mult='1' m='1'

ribias_short
+ IBIAS tail
+ 0.001
* No parameters

.ENDS

.SUBCKT SecondStage_6e3fcde278d5dba6851abcdeaf1406de_
+ VIN VOUT IBIAS VDD VSS
* No parameters

xm_load
+ VOUT IBIAS VSS VSS
+ sky130_fd_pr__nfet_01v8
+ w='0.400e1' l='4' nf='1' ad='int((nf+1)/2) * w/nf * 0.29' As='int((nf+2)/2) * w/nf * 0.29' pd='2*int((nf+1)/2) * (w/nf + 0.29)' ps='2*int((nf+2)/2) * (w/nf + 0.29)' nrd='0.29 / w' nrs='0.29 / w' sa='0' sb='0' sd='0' mult='1' m='1'

xm_amp
+ VOUT VIN VDD VDD
+ sky130_fd_pr__pfet_01v8
+ w='2' l='2' nf='1' ad='int((nf+1)/2) * w/nf * 0.29' As='int((nf+2)/2) * w/nf * 0.29' pd='2*int((nf+1)/2) * (w/nf + 0.29)' ps='2*int((nf+2)/2) * (w/nf + 0.29)' nrd='0.29 / w' nrs='0.29 / w' sa='0' sb='0' sd='0' mult='1' m='1'

ribias_probe
+ IBIAS VSS
+ 1000000000
* No parameters

.ENDS

.SUBCKT OutputStage_19445cd049ec96446328158dc8ac64cf_
+ VIN VOUT IBIAS VDD VSS
* No parameters

xm_load
+ VOUT IBIAS VSS VSS
+ sky130_fd_pr__nfet_01v8
+ w='1.200e1' l='1' nf='1' ad='int((nf+1)/2) * w/nf * 0.29' As='int((nf+2)/2) * w/nf * 0.29' pd='2*int((nf+1)/2) * (w/nf + 0.29)' ps='2*int((nf+2)/2) * (w/nf + 0.29)' nrd='0.29 / w' nrs='0.29 / w' sa='0' sb='0' sd='0' mult='1' m='1'

xm_amp
+ VOUT VIN VDD VDD
+ sky130_fd_pr__pfet_01v8
+ w='4' l='1' nf='1' ad='int((nf+1)/2) * w/nf * 0.29' As='int((nf+2)/2) * w/nf * 0.29' pd='2*int((nf+1)/2) * (w/nf + 0.29)' ps='2*int((nf+2)/2) * (w/nf + 0.29)' nrd='0.29 / w' nrs='0.29 / w' sa='0' sb='0' sd='0' mult='1' m='1'

ribias_probe
+ IBIAS VSS
+ 1000000000
* No parameters

.ENDS

.SUBCKT FreqComp_6a14f77ab1f7285608cf68e1752959d4_
+ V1 VOUT
* No parameters

ccc
+ V1 VOUT
+ 2E-13
* No parameters

.ENDS

.SUBCKT OpampCore_a5ed26996e6d06dc52d6a11f91eb641f_
+ VINP VINN VOUT EN VDD VSS
* No parameters

xxbias
+ VDD VSS EN ibias1 ibias2
+ BiasGen_64cfaf1eea1456c9c03bb1fbdcd87139_
* No parameters

xxgain
+ VINP VINN vx vref ibias1 VDD VSS
+ GainStage_f794943be3f5a2f9aaba194e889e908d_
* No parameters

rrvcm_top
+ VDD vcm
+ 10000000
* No parameters

rrvcm_bot
+ vcm VSS
+ 10000000
* No parameters

xbias2_ref
+ vbias2 vbias2 VSS VSS
+ sky130_fd_pr__nfet_01v8
+ w='2' l='2' nf='1' ad='int((nf+1)/2) * w/nf * 0.29' As='int((nf+2)/2) * w/nf * 0.29' pd='2*int((nf+1)/2) * (w/nf + 0.29)' ps='2*int((nf+2)/2) * (w/nf + 0.29)' nrd='0.29 / w' nrs='0.29 / w' sa='0' sb='0' sd='0' mult='1' m='1'

rbias2_short
+ ibias2 vbias2
+ 0.001
* No parameters

xxsecond
+ vx v2 vbias2 VDD VSS
+ SecondStage_6e3fcde278d5dba6851abcdeaf1406de_
* No parameters

xxout
+ v2 VOUT vbias2 VDD VSS
+ OutputStage_19445cd049ec96446328158dc8ac64cf_
* No parameters

xxcomp
+ vx v2
+ FreqComp_6a14f77ab1f7285608cf68e1752959d4_
* No parameters

rbleed_vx
+ vx vcm
+ 5000000
* No parameters

rbleed_vref
+ vref vcm
+ 5000000
* No parameters

rbleed_v2
+ v2 vcm
+ 5000000
* No parameters

rbleed_vout
+ VOUT vcm
+ 5000000
* No parameters

.ENDS
