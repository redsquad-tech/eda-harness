* Anonymous `circuit.Package`
* Generated by `vlsirtools.SpiceNetlister`
*

.SUBCKT CmosInv_3e3a48af070f445359b4b2b4e367924b_
+ i o avdd agnd
* No parameters

xmp
+ o i avdd avdd
+ sky130_fd_pr__pfet_01v8
+ w='1' l='0.5' nf='1' ad='int((nf+1)/2) * w/nf * 0.29' As='int((nf+2)/2) * w/nf * 0.29' pd='2*int((nf+1)/2) * (w/nf + 0.29)' ps='2*int((nf+2)/2) * (w/nf + 0.29)' nrd='0.29 / w' nrs='0.29 / w' sa='0' sb='0' sd='0' mult='1' m='1'

xmn
+ o i agnd agnd
+ sky130_fd_pr__nfet_01v8
+ w='0.6' l='0.5' nf='1' ad='int((nf+1)/2) * w/nf * 0.29' As='int((nf+2)/2) * w/nf * 0.29' pd='2*int((nf+1)/2) * (w/nf + 0.29)' ps='2*int((nf+2)/2) * (w/nf + 0.29)' nrd='0.29 / w' nrs='0.29 / w' sa='0' sb='0' sd='0' mult='1' m='1'

.ENDS

.SUBCKT TransmissionGate_d52d31bff2475ecb5dddf7ead41b46a2_
+ a b en en_b avdd agnd
* No parameters

xpsw
+ a en_b b avdd
+ sky130_fd_pr__pfet_01v8
+ w='4' l='0.3' nf='1' ad='int((nf+1)/2) * w/nf * 0.29' As='int((nf+2)/2) * w/nf * 0.29' pd='2*int((nf+1)/2) * (w/nf + 0.29)' ps='2*int((nf+2)/2) * (w/nf + 0.29)' nrd='0.29 / w' nrs='0.29 / w' sa='0' sb='0' sd='0' mult='1' m='1'

xnsw
+ a en b agnd
+ sky130_fd_pr__nfet_01v8
+ w='3' l='0.3' nf='1' ad='int((nf+1)/2) * w/nf * 0.29' As='int((nf+2)/2) * w/nf * 0.29' pd='2*int((nf+1)/2) * (w/nf + 0.29)' ps='2*int((nf+2)/2) * (w/nf + 0.29)' nrd='0.29 / w' nrs='0.29 / w' sa='0' sb='0' sd='0' mult='1' m='1'

.ENDS

.SUBCKT _OpaBiasGen_720a25a1579e6cae6fc79d1d44be67b6_
+ avdd agnd iref i0_p i0_n ibias_p ibias_n vbias1 vbias2 vbias3
* No parameters

xmp_ref
+ iref iref avdd avdd
+ sky130_fd_pr__pfet_01v8
+ w='1.2' l='2' nf='1' ad='int((nf+1)/2) * w/nf * 0.29' As='int((nf+2)/2) * w/nf * 0.29' pd='2*int((nf+1)/2) * (w/nf + 0.29)' ps='2*int((nf+2)/2) * (w/nf + 0.29)' nrd='0.29 / w' nrs='0.29 / w' sa='0' sb='0' sd='0' mult='1' m='1'

xmp_nref_feed
+ nref iref avdd avdd
+ sky130_fd_pr__pfet_01v8
+ w='1' l='2' nf='1' ad='int((nf+1)/2) * w/nf * 0.29' As='int((nf+2)/2) * w/nf * 0.29' pd='2*int((nf+1)/2) * (w/nf + 0.29)' ps='2*int((nf+2)/2) * (w/nf + 0.29)' nrd='0.29 / w' nrs='0.29 / w' sa='0' sb='0' sd='0' mult='1' m='1'

xmn_ref
+ nref nref agnd agnd
+ sky130_fd_pr__nfet_01v8
+ w='0.9' l='1.5' nf='1' ad='int((nf+1)/2) * w/nf * 0.29' As='int((nf+2)/2) * w/nf * 0.29' pd='2*int((nf+1)/2) * (w/nf + 0.29)' ps='2*int((nf+2)/2) * (w/nf + 0.29)' nrd='0.29 / w' nrs='0.29 / w' sa='0' sb='0' sd='0' mult='1' m='1'

xmp_i0_p_ref
+ vg_i0_p vg_i0_p avdd avdd
+ sky130_fd_pr__pfet_01v8_hvt
+ w='3' l='0.8' nf='1' ad='int((nf+1)/2) * w/nf * 0.29' As='int((nf+2)/2) * w/nf * 0.29' pd='2*int((nf+1)/2) * (w/nf + 0.29)' ps='2*int((nf+2)/2) * (w/nf + 0.29)' nrd='0.29 / w' nrs='0.29 / w' sa='0' sb='0' sd='0' mult='1' m='1'

xmn_i0_p_sink
+ vg_i0_p nref agnd agnd
+ sky130_fd_pr__nfet_01v8
+ w='0.9' l='1.5' nf='1' ad='int((nf+1)/2) * w/nf * 0.29' As='int((nf+2)/2) * w/nf * 0.29' pd='2*int((nf+1)/2) * (w/nf + 0.29)' ps='2*int((nf+2)/2) * (w/nf + 0.29)' nrd='0.29 / w' nrs='0.29 / w' sa='0' sb='0' sd='0' mult='1' m='1'

xmp_i0_p_out
+ i0_p vg_i0_p avdd avdd
+ sky130_fd_pr__pfet_01v8_hvt
+ w='3' l='0.8' nf='1' ad='int((nf+1)/2) * w/nf * 0.29' As='int((nf+2)/2) * w/nf * 0.29' pd='2*int((nf+1)/2) * (w/nf + 0.29)' ps='2*int((nf+2)/2) * (w/nf + 0.29)' nrd='0.29 / w' nrs='0.29 / w' sa='0' sb='0' sd='0' mult='1' m='1'

xmp_ibias_p_ref
+ vg_ibias_p vg_ibias_p avdd avdd
+ sky130_fd_pr__pfet_01v8_hvt
+ w='1.5' l='1' nf='1' ad='int((nf+1)/2) * w/nf * 0.29' As='int((nf+2)/2) * w/nf * 0.29' pd='2*int((nf+1)/2) * (w/nf + 0.29)' ps='2*int((nf+2)/2) * (w/nf + 0.29)' nrd='0.29 / w' nrs='0.29 / w' sa='0' sb='0' sd='0' mult='1' m='1'

xmn_ibias_p_sink
+ vg_ibias_p nref agnd agnd
+ sky130_fd_pr__nfet_01v8
+ w='0.9' l='1.5' nf='1' ad='int((nf+1)/2) * w/nf * 0.29' As='int((nf+2)/2) * w/nf * 0.29' pd='2*int((nf+1)/2) * (w/nf + 0.29)' ps='2*int((nf+2)/2) * (w/nf + 0.29)' nrd='0.29 / w' nrs='0.29 / w' sa='0' sb='0' sd='0' mult='1' m='1'

xmp_ibias_p_out
+ ibias_p vg_ibias_p avdd avdd
+ sky130_fd_pr__pfet_01v8_hvt
+ w='1.5' l='1' nf='1' ad='int((nf+1)/2) * w/nf * 0.29' As='int((nf+2)/2) * w/nf * 0.29' pd='2*int((nf+1)/2) * (w/nf + 0.29)' ps='2*int((nf+2)/2) * (w/nf + 0.29)' nrd='0.29 / w' nrs='0.29 / w' sa='0' sb='0' sd='0' mult='1' m='1'

xmp_bias1
+ vbias1 vbias1 avdd avdd
+ sky130_fd_pr__pfet_01v8_hvt
+ w='4' l='0.6' nf='1' ad='int((nf+1)/2) * w/nf * 0.29' As='int((nf+2)/2) * w/nf * 0.29' pd='2*int((nf+1)/2) * (w/nf + 0.29)' ps='2*int((nf+2)/2) * (w/nf + 0.29)' nrd='0.29 / w' nrs='0.29 / w' sa='0' sb='0' sd='0' mult='1' m='1'

xmn_bias1_sink
+ vbias1 nref agnd agnd
+ sky130_fd_pr__nfet_01v8
+ w='0.9' l='1.5' nf='1' ad='int((nf+1)/2) * w/nf * 0.29' As='int((nf+2)/2) * w/nf * 0.29' pd='2*int((nf+1)/2) * (w/nf + 0.29)' ps='2*int((nf+2)/2) * (w/nf + 0.29)' nrd='0.29 / w' nrs='0.29 / w' sa='0' sb='0' sd='0' mult='1' m='1'

xmp_bias2
+ vbias2 vbias2 avdd avdd
+ sky130_fd_pr__pfet_01v8
+ w='4' l='0.6' nf='1' ad='int((nf+1)/2) * w/nf * 0.29' As='int((nf+2)/2) * w/nf * 0.29' pd='2*int((nf+1)/2) * (w/nf + 0.29)' ps='2*int((nf+2)/2) * (w/nf + 0.29)' nrd='0.29 / w' nrs='0.29 / w' sa='0' sb='0' sd='0' mult='1' m='1'

xmn_bias2_sink
+ vbias2 nref agnd agnd
+ sky130_fd_pr__nfet_01v8
+ w='0.9' l='1.5' nf='1' ad='int((nf+1)/2) * w/nf * 0.29' As='int((nf+2)/2) * w/nf * 0.29' pd='2*int((nf+1)/2) * (w/nf + 0.29)' ps='2*int((nf+2)/2) * (w/nf + 0.29)' nrd='0.29 / w' nrs='0.29 / w' sa='0' sb='0' sd='0' mult='1' m='1'

xmp_i0_n_feed
+ vg_i0_n iref avdd avdd
+ sky130_fd_pr__pfet_01v8
+ w='2' l='0.8' nf='1' ad='int((nf+1)/2) * w/nf * 0.29' As='int((nf+2)/2) * w/nf * 0.29' pd='2*int((nf+1)/2) * (w/nf + 0.29)' ps='2*int((nf+2)/2) * (w/nf + 0.29)' nrd='0.29 / w' nrs='0.29 / w' sa='0' sb='0' sd='0' mult='1' m='1'

xmn_i0_n_ref
+ vg_i0_n vg_i0_n agnd agnd
+ sky130_fd_pr__nfet_01v8
+ w='2' l='0.8' nf='1' ad='int((nf+1)/2) * w/nf * 0.29' As='int((nf+2)/2) * w/nf * 0.29' pd='2*int((nf+1)/2) * (w/nf + 0.29)' ps='2*int((nf+2)/2) * (w/nf + 0.29)' nrd='0.29 / w' nrs='0.29 / w' sa='0' sb='0' sd='0' mult='1' m='1'

xmn_i0_n_out
+ i0_n vg_i0_n agnd agnd
+ sky130_fd_pr__nfet_01v8
+ w='2' l='0.8' nf='1' ad='int((nf+1)/2) * w/nf * 0.29' As='int((nf+2)/2) * w/nf * 0.29' pd='2*int((nf+1)/2) * (w/nf + 0.29)' ps='2*int((nf+2)/2) * (w/nf + 0.29)' nrd='0.29 / w' nrs='0.29 / w' sa='0' sb='0' sd='0' mult='1' m='1'

xmp_ibias_n_feed
+ vg_ibias_n iref avdd avdd
+ sky130_fd_pr__pfet_01v8
+ w='1' l='1' nf='1' ad='int((nf+1)/2) * w/nf * 0.29' As='int((nf+2)/2) * w/nf * 0.29' pd='2*int((nf+1)/2) * (w/nf + 0.29)' ps='2*int((nf+2)/2) * (w/nf + 0.29)' nrd='0.29 / w' nrs='0.29 / w' sa='0' sb='0' sd='0' mult='1' m='1'

xmn_ibias_n_ref
+ vg_ibias_n vg_ibias_n agnd agnd
+ sky130_fd_pr__nfet_01v8
+ w='1' l='1' nf='1' ad='int((nf+1)/2) * w/nf * 0.29' As='int((nf+2)/2) * w/nf * 0.29' pd='2*int((nf+1)/2) * (w/nf + 0.29)' ps='2*int((nf+2)/2) * (w/nf + 0.29)' nrd='0.29 / w' nrs='0.29 / w' sa='0' sb='0' sd='0' mult='1' m='1'

xmn_ibias_n_out
+ ibias_n vg_ibias_n agnd agnd
+ sky130_fd_pr__nfet_01v8
+ w='1' l='1' nf='1' ad='int((nf+1)/2) * w/nf * 0.29' As='int((nf+2)/2) * w/nf * 0.29' pd='2*int((nf+1)/2) * (w/nf + 0.29)' ps='2*int((nf+2)/2) * (w/nf + 0.29)' nrd='0.29 / w' nrs='0.29 / w' sa='0' sb='0' sd='0' mult='1' m='1'

xmp_bias3_feed
+ vbias3 iref avdd avdd
+ sky130_fd_pr__pfet_01v8
+ w='3' l='0.6' nf='1' ad='int((nf+1)/2) * w/nf * 0.29' As='int((nf+2)/2) * w/nf * 0.29' pd='2*int((nf+1)/2) * (w/nf + 0.29)' ps='2*int((nf+2)/2) * (w/nf + 0.29)' nrd='0.29 / w' nrs='0.29 / w' sa='0' sb='0' sd='0' mult='1' m='1'

xmn_bias3
+ vbias3 vbias3 agnd agnd
+ sky130_fd_pr__nfet_01v8
+ w='3' l='0.6' nf='1' ad='int((nf+1)/2) * w/nf * 0.29' As='int((nf+2)/2) * w/nf * 0.29' pd='2*int((nf+1)/2) * (w/nf + 0.29)' ps='2*int((nf+2)/2) * (w/nf + 0.29)' nrd='0.29 / w' nrs='0.29 / w' sa='0' sb='0' sd='0' mult='1' m='1'

.ENDS

.SUBCKT ComplementaryCascodeFrontEnd_32e778271097915d8e40f8accd4f9a24_
+ vinp vinn avdd agnd tail_p tail_n vbias1 vbias2 vbias3 vgp vgn
* No parameters

xpinp_l
+ nnode_l vinn tail_p avdd
+ sky130_fd_pr__pfet_01v8_lvt
+ w='8' l='0.5' nf='1' ad='int((nf+1)/2) * w/nf * 0.29' As='int((nf+2)/2) * w/nf * 0.29' pd='2*int((nf+1)/2) * (w/nf + 0.29)' ps='2*int((nf+2)/2) * (w/nf + 0.29)' nrd='0.29 / w' nrs='0.29 / w' sa='0' sb='0' sd='0' mult='1' m='1'

xpinp_r
+ nnode_r vinp tail_p avdd
+ sky130_fd_pr__pfet_01v8_lvt
+ w='8' l='0.5' nf='1' ad='int((nf+1)/2) * w/nf * 0.29' As='int((nf+2)/2) * w/nf * 0.29' pd='2*int((nf+1)/2) * (w/nf + 0.29)' ps='2*int((nf+2)/2) * (w/nf + 0.29)' nrd='0.29 / w' nrs='0.29 / w' sa='0' sb='0' sd='0' mult='1' m='1'

xninp_l
+ pnode_l vinp tail_n agnd
+ sky130_fd_pr__nfet_01v8_lvt
+ w='4' l='0.5' nf='1' ad='int((nf+1)/2) * w/nf * 0.29' As='int((nf+2)/2) * w/nf * 0.29' pd='2*int((nf+1)/2) * (w/nf + 0.29)' ps='2*int((nf+2)/2) * (w/nf + 0.29)' nrd='0.29 / w' nrs='0.29 / w' sa='0' sb='0' sd='0' mult='1' m='1'

xninp_r
+ pnode_r vinn tail_n agnd
+ sky130_fd_pr__nfet_01v8_lvt
+ w='4' l='0.5' nf='1' ad='int((nf+1)/2) * w/nf * 0.29' As='int((nf+2)/2) * w/nf * 0.29' pd='2*int((nf+1)/2) * (w/nf + 0.29)' ps='2*int((nf+2)/2) * (w/nf + 0.29)' nrd='0.29 / w' nrs='0.29 / w' sa='0' sb='0' sd='0' mult='1' m='1'

xmpb1_l
+ pnode_l vbias1 avdd avdd
+ sky130_fd_pr__pfet_01v8_hvt
+ w='4' l='0.6' nf='1' ad='int((nf+1)/2) * w/nf * 0.29' As='int((nf+2)/2) * w/nf * 0.29' pd='2*int((nf+1)/2) * (w/nf + 0.29)' ps='2*int((nf+2)/2) * (w/nf + 0.29)' nrd='0.29 / w' nrs='0.29 / w' sa='0' sb='0' sd='0' mult='1' m='1'

xmpb1_r
+ pnode_r vbias1 avdd avdd
+ sky130_fd_pr__pfet_01v8_hvt
+ w='4' l='0.6' nf='1' ad='int((nf+1)/2) * w/nf * 0.29' As='int((nf+2)/2) * w/nf * 0.29' pd='2*int((nf+1)/2) * (w/nf + 0.29)' ps='2*int((nf+2)/2) * (w/nf + 0.29)' nrd='0.29 / w' nrs='0.29 / w' sa='0' sb='0' sd='0' mult='1' m='1'

xmpb2_l
+ vref_mid vbias2 pnode_l avdd
+ sky130_fd_pr__pfet_01v8
+ w='4' l='0.6' nf='1' ad='int((nf+1)/2) * w/nf * 0.29' As='int((nf+2)/2) * w/nf * 0.29' pd='2*int((nf+1)/2) * (w/nf + 0.29)' ps='2*int((nf+2)/2) * (w/nf + 0.29)' nrd='0.29 / w' nrs='0.29 / w' sa='0' sb='0' sd='0' mult='1' m='1'

xmpb2_r
+ vgp vbias2 pnode_r avdd
+ sky130_fd_pr__pfet_01v8
+ w='4' l='0.6' nf='1' ad='int((nf+1)/2) * w/nf * 0.29' As='int((nf+2)/2) * w/nf * 0.29' pd='2*int((nf+1)/2) * (w/nf + 0.29)' ps='2*int((nf+2)/2) * (w/nf + 0.29)' nrd='0.29 / w' nrs='0.29 / w' sa='0' sb='0' sd='0' mult='1' m='1'

xmnb3_l
+ vref_mid vbias3 nnode_l agnd
+ sky130_fd_pr__nfet_01v8
+ w='3' l='0.6' nf='1' ad='int((nf+1)/2) * w/nf * 0.29' As='int((nf+2)/2) * w/nf * 0.29' pd='2*int((nf+1)/2) * (w/nf + 0.29)' ps='2*int((nf+2)/2) * (w/nf + 0.29)' nrd='0.29 / w' nrs='0.29 / w' sa='0' sb='0' sd='0' mult='1' m='1'

xmnb3_r
+ vgn vbias3 nnode_r agnd
+ sky130_fd_pr__nfet_01v8
+ w='3' l='0.6' nf='1' ad='int((nf+1)/2) * w/nf * 0.29' As='int((nf+2)/2) * w/nf * 0.29' pd='2*int((nf+1)/2) * (w/nf + 0.29)' ps='2*int((nf+2)/2) * (w/nf + 0.29)' nrd='0.29 / w' nrs='0.29 / w' sa='0' sb='0' sd='0' mult='1' m='1'

xmnref
+ nnode_l nnode_l agnd agnd
+ sky130_fd_pr__nfet_01v8
+ w='3' l='0.6' nf='1' ad='int((nf+1)/2) * w/nf * 0.29' As='int((nf+2)/2) * w/nf * 0.29' pd='2*int((nf+1)/2) * (w/nf + 0.29)' ps='2*int((nf+2)/2) * (w/nf + 0.29)' nrd='0.29 / w' nrs='0.29 / w' sa='0' sb='0' sd='0' mult='1' m='1'

xmnout
+ nnode_r nnode_l agnd agnd
+ sky130_fd_pr__nfet_01v8
+ w='3' l='0.6' nf='1' ad='int((nf+1)/2) * w/nf * 0.29' As='int((nf+2)/2) * w/nf * 0.29' pd='2*int((nf+1)/2) * (w/nf + 0.29)' ps='2*int((nf+2)/2) * (w/nf + 0.29)' nrd='0.29 / w' nrs='0.29 / w' sa='0' sb='0' sd='0' mult='1' m='1'

.ENDS

.SUBCKT MonticelliCell_9a59a007fdd2327de22408edf89cfe31_
+ vb_m24 vb_m35 vgp vgn avdd agnd
* No parameters

xmn22
+ vb_m24 vb_m24 n_mid agnd
+ sky130_fd_pr__nfet_01v8
+ w='1' l='0.6' nf='1' ad='int((nf+1)/2) * w/nf * 0.29' As='int((nf+2)/2) * w/nf * 0.29' pd='2*int((nf+1)/2) * (w/nf + 0.29)' ps='2*int((nf+2)/2) * (w/nf + 0.29)' nrd='0.29 / w' nrs='0.29 / w' sa='0' sb='0' sd='0' mult='1' m='1'

xmn23
+ n_mid n_mid agnd agnd
+ sky130_fd_pr__nfet_01v8
+ w='1' l='0.6' nf='1' ad='int((nf+1)/2) * w/nf * 0.29' As='int((nf+2)/2) * w/nf * 0.29' pd='2*int((nf+1)/2) * (w/nf + 0.29)' ps='2*int((nf+2)/2) * (w/nf + 0.29)' nrd='0.29 / w' nrs='0.29 / w' sa='0' sb='0' sd='0' mult='1' m='1'

xmp33
+ p_mid p_mid avdd avdd
+ sky130_fd_pr__pfet_01v8_hvt
+ w='1.5' l='0.6' nf='1' ad='int((nf+1)/2) * w/nf * 0.29' As='int((nf+2)/2) * w/nf * 0.29' pd='2*int((nf+1)/2) * (w/nf + 0.29)' ps='2*int((nf+2)/2) * (w/nf + 0.29)' nrd='0.29 / w' nrs='0.29 / w' sa='0' sb='0' sd='0' mult='1' m='1'

xmp34
+ vb_m35 vb_m35 p_mid avdd
+ sky130_fd_pr__pfet_01v8_hvt
+ w='1.5' l='0.6' nf='1' ad='int((nf+1)/2) * w/nf * 0.29' As='int((nf+2)/2) * w/nf * 0.29' pd='2*int((nf+1)/2) * (w/nf + 0.29)' ps='2*int((nf+2)/2) * (w/nf + 0.29)' nrd='0.29 / w' nrs='0.29 / w' sa='0' sb='0' sd='0' mult='1' m='1'

xm24
+ vgp vb_m24 vgn agnd
+ sky130_fd_pr__nfet_01v8
+ w='1.5' l='0.6' nf='1' ad='int((nf+1)/2) * w/nf * 0.29' As='int((nf+2)/2) * w/nf * 0.29' pd='2*int((nf+1)/2) * (w/nf + 0.29)' ps='2*int((nf+2)/2) * (w/nf + 0.29)' nrd='0.29 / w' nrs='0.29 / w' sa='0' sb='0' sd='0' mult='1' m='1'

xm35
+ vgn vb_m35 vgp avdd
+ sky130_fd_pr__pfet_01v8
+ w='3' l='0.6' nf='1' ad='int((nf+1)/2) * w/nf * 0.29' As='int((nf+2)/2) * w/nf * 0.29' pd='2*int((nf+1)/2) * (w/nf + 0.29)' ps='2*int((nf+2)/2) * (w/nf + 0.29)' nrd='0.29 / w' nrs='0.29 / w' sa='0' sb='0' sd='0' mult='1' m='1'

.ENDS

.SUBCKT ClassAbOutputStage_354047d76e2535aa482ce11fd20a1a8c_
+ vgp vgn vout avdd agnd
* No parameters

xm2
+ vout vgp avdd avdd
+ sky130_fd_pr__pfet_01v8
+ w='16' l='0.6' nf='1' ad='int((nf+1)/2) * w/nf * 0.29' As='int((nf+2)/2) * w/nf * 0.29' pd='2*int((nf+1)/2) * (w/nf + 0.29)' ps='2*int((nf+2)/2) * (w/nf + 0.29)' nrd='0.29 / w' nrs='0.29 / w' sa='0' sb='0' sd='0' mult='1' m='1'

xm1
+ vout vgn agnd agnd
+ sky130_fd_pr__nfet_01v8
+ w='8' l='0.6' nf='1' ad='int((nf+1)/2) * w/nf * 0.29' As='int((nf+2)/2) * w/nf * 0.29' pd='2*int((nf+1)/2) * (w/nf + 0.29)' ps='2*int((nf+2)/2) * (w/nf + 0.29)' nrd='0.29 / w' nrs='0.29 / w' sa='0' sb='0' sd='0' mult='1' m='1'

rrcp
+ vgp ccp_mid
+ 12000
* No parameters

cccp
+ ccp_mid vout
+ 9f
* No parameters

rrcn
+ vgn ccn_mid
+ 12000
* No parameters

cccn
+ ccn_mid vout
+ 9f
* No parameters

.ENDS

.SUBCKT NmosSwitch_9f68c3341eab878a6a6a3d424d9e8fe7_
+ a b en agnd
* No parameters

xsw
+ a en b agnd
+ sky130_fd_pr__nfet_01v8
+ w='4' l='0.3' nf='1' ad='int((nf+1)/2) * w/nf * 0.29' As='int((nf+2)/2) * w/nf * 0.29' pd='2*int((nf+1)/2) * (w/nf + 0.29)' ps='2*int((nf+2)/2) * (w/nf + 0.29)' nrd='0.29 / w' nrs='0.29 / w' sa='0' sb='0' sd='0' mult='1' m='1'

.ENDS

.SUBCKT PmosSwitch_9f68c3341eab878a6a6a3d424d9e8fe7_
+ a b en_b avdd
* No parameters

xsw
+ a en_b b avdd
+ sky130_fd_pr__pfet_01v8
+ w='5' l='0.3' nf='1' ad='int((nf+1)/2) * w/nf * 0.29' As='int((nf+2)/2) * w/nf * 0.29' pd='2*int((nf+1)/2) * (w/nf + 0.29)' ps='2*int((nf+2)/2) * (w/nf + 0.29)' nrd='0.29 / w' nrs='0.29 / w' sa='0' sb='0' sd='0' mult='1' m='1'

.ENDS

.SUBCKT NeuronCoreOaSky130_4f6ed3d2a22f7fd4752668b8eace8b8f_
+ avdd1p2 agnd vinp vinn vout in0u25_oa vbase vfeed d_en_oa d_az_oa d_inf_oa vtest d_treset_oa d_tcki d_tcko d_tdi d_tdo
* No parameters

xinv_en
+ d_en_oa d_en_b avdd1p2 agnd
+ CmosInv_3e3a48af070f445359b4b2b4e367924b_
* No parameters

xinv_az
+ d_az_oa d_az_b avdd1p2 agnd
+ CmosInv_3e3a48af070f445359b4b2b4e367924b_
* No parameters

xinv_inf
+ d_inf_oa d_inf_b avdd1p2 agnd
+ CmosInv_3e3a48af070f445359b4b2b4e367924b_
* No parameters

xinv_tdi
+ d_tdi d_tdi_b avdd1p2 agnd
+ CmosInv_3e3a48af070f445359b4b2b4e367924b_
* No parameters

xiref_sw
+ in0u25_oa iref_int d_en_oa d_en_b avdd1p2 agnd
+ TransmissionGate_d52d31bff2475ecb5dddf7ead41b46a2_
* No parameters

xbias
+ avdd1p2 agnd iref_int tail_p tail_n vb_m24 vb_m35 vbias1 vbias2 vbias3
+ _OpaBiasGen_720a25a1579e6cae6fc79d1d44be67b6_
* No parameters

xfrontend
+ vinp vinn avdd1p2 agnd tail_p tail_n vbias1 vbias2 vbias3 vgp vgn
+ ComplementaryCascodeFrontEnd_32e778271097915d8e40f8accd4f9a24_
* No parameters

xaz_short
+ vgp vgn d_az_oa d_az_b avdd1p2 agnd
+ TransmissionGate_d52d31bff2475ecb5dddf7ead41b46a2_
* No parameters

xmont
+ vb_m24 vb_m35 vgp vgn avdd1p2 agnd
+ MonticelliCell_9a59a007fdd2327de22408edf89cfe31_
* No parameters

xoutput_stage
+ vgp vgn vout avdd1p2 agnd
+ ClassAbOutputStage_354047d76e2535aa482ce11fd20a1a8c_
* No parameters

xvbase_sw
+ vbase agnd d_inf_oa agnd
+ NmosSwitch_9f68c3341eab878a6a6a3d424d9e8fe7_
* No parameters

xvfeed_sw
+ avdd1p2 vfeed d_inf_b avdd1p2
+ PmosSwitch_9f68c3341eab878a6a6a3d424d9e8fe7_
* No parameters

xvout_to_vtest
+ vout vtest d_tdi d_tdi_b avdd1p2 agnd
+ TransmissionGate_d52d31bff2475ecb5dddf7ead41b46a2_
* No parameters

rtck_short
+ d_tcki d_tcko
+ 0.001
* No parameters

rtdi_short
+ d_tdi d_tdo
+ 0.001
* No parameters

.ENDS
