* `ngspice` Sim Input for `opamp.v3.prod.opamp_az_top.Tb`
* Generated by `vlsirtools.CompatibleNgspiceNetlister`
*
* Anonymous `circuit.Package`
* Generated by `vlsirtools.CompatibleNgspiceNetlister`
*

.SUBCKT TgSwitch_27b2fcc49df85135e3d949bb443941ef_
+ A B PHI PHIB VDD VSS
* No parameters

xsw_n
+ A PHI B VSS
+ sky130_fd_pr__nfet_01v8
+ w='1.1' l='0.15' nf='2' ad='int((nf+1)/2) * w/nf * 0.29' As='int((nf+2)/2) * w/nf * 0.29' pd='2*int((nf+1)/2) * (w/nf + 0.29)' ps='2*int((nf+2)/2) * (w/nf + 0.29)' nrd='0.29 / w' nrs='0.29 / w' sa='0' sb='0' sd='0' mult='1' m='1'

xsw_p
+ A PHIB B VDD
+ sky130_fd_pr__pfet_01v8
+ w='1.6' l='0.15' nf='2' ad='int((nf+1)/2) * w/nf * 0.29' As='int((nf+2)/2) * w/nf * 0.29' pd='2*int((nf+1)/2) * (w/nf + 0.29)' ps='2*int((nf+2)/2) * (w/nf + 0.29)' nrd='0.29 / w' nrs='0.29 / w' sa='0' sb='0' sd='0' mult='1' m='1'

.ENDS

.SUBCKT SampleHoldCap_c439be8ae28927aae3d672232b043574_
+ P N
* No parameters

xcap_0
+ P N
+ sky130_fd_pr__cap_mim_m3_1
+ w='3' l='3' mf='1'

.ENDS

.SUBCKT FrontendAzV3_95d94e55881d0f557dc14f96e68b57a7_
+ VINP VINN VOFF VXP VXN PHI1 PHI1B PHI2 PHI2B PHI3 PHI3B VDD VSS
* No parameters

rrvoff_top
+ VOFF voff_sense
+ 600
* No parameters

rrvoff_bot
+ voff_sense VSS
+ 5
* No parameters

xxsw_err_sample
+ voff_sense samp_p PHI1 PHI1B VDD VSS
+ TgSwitch_27b2fcc49df85135e3d949bb443941ef_
* No parameters

xxsw_vxp_reset
+ VSS vxp_sc PHI1 PHI1B VDD VSS
+ TgSwitch_27b2fcc49df85135e3d949bb443941ef_
* No parameters

xxsw_vxp_apply
+ VINP samp_p PHI3 PHI3B VDD VSS
+ TgSwitch_27b2fcc49df85135e3d949bb443941ef_
* No parameters

xxcap_p_phys
+ samp_p vxp_sc
+ SampleHoldCap_c439be8ae28927aae3d672232b043574_
* No parameters

cxcap_p
+ samp_p vxp_sc
+ 3E-13
* No parameters

rrout_p
+ vxp_sc VXP
+ 1
* No parameters

ccout_p
+ VXP VSS
+ 1E-14
* No parameters

xxsw_vxn_reset
+ VSS vxn_sc PHI1 PHI1B VDD VSS
+ TgSwitch_27b2fcc49df85135e3d949bb443941ef_
* No parameters

xxsw_vxn_track
+ VINN vxn_sc PHI3 PHI3B VDD VSS
+ TgSwitch_27b2fcc49df85135e3d949bb443941ef_
* No parameters

xxcap_n_phys
+ vxn_sc VSS
+ SampleHoldCap_c439be8ae28927aae3d672232b043574_
* No parameters

cxcap_n
+ vxn_sc VSS
+ 0.15000000000000p
* No parameters

rrout_n
+ vxn_sc VXN
+ 1
* No parameters

rrbleed_p
+ VXP VSS
+ 500000000
* No parameters

rrbleed_n
+ VXN VSS
+ 500000000
* No parameters

.ENDS

.SUBCKT DiffpairP_7d3f4fa52beb1249cfa0798f031fdeeb_
+ INP INN OUTP OUTN TAIL VDD VSS
* No parameters

rshort_p
+ TAIL srcp
+ 0.001
* No parameters

rshort_n
+ TAIL srcn
+ 0.001
* No parameters

xmp
+ OUTP INP srcp VDD
+ sky130_fd_pr__pfet_01v8
+ w='10' l='3' nf='1' ad='int((nf+1)/2) * w/nf * 0.29' As='int((nf+2)/2) * w/nf * 0.29' pd='2*int((nf+1)/2) * (w/nf + 0.29)' ps='2*int((nf+2)/2) * (w/nf + 0.29)' nrd='0.29 / w' nrs='0.29 / w' sa='0' sb='0' sd='0' mult='1' m='1'

xmn
+ OUTN INN srcn VDD
+ sky130_fd_pr__pfet_01v8
+ w='10' l='3' nf='1' ad='int((nf+1)/2) * w/nf * 0.29' As='int((nf+2)/2) * w/nf * 0.29' pd='2*int((nf+1)/2) * (w/nf + 0.29)' ps='2*int((nf+2)/2) * (w/nf + 0.29)' nrd='0.29 / w' nrs='0.29 / w' sa='0' sb='0' sd='0' mult='1' m='1'

.ENDS

.SUBCKT OpampCoreV3_c43733b6dd8b7d40d75df6a5d7623f30_
+ VINP VINN VOUT EN VDD VSS
* No parameters

xm_enb_p
+ enb EN VDD VDD
+ sky130_fd_pr__pfet_01v8
+ w='2' l='0.15' nf='1' ad='int((nf+1)/2) * w/nf * 0.29' As='int((nf+2)/2) * w/nf * 0.29' pd='2*int((nf+1)/2) * (w/nf + 0.29)' ps='2*int((nf+2)/2) * (w/nf + 0.29)' nrd='0.29 / w' nrs='0.29 / w' sa='0' sb='0' sd='0' mult='1' m='1'

xm_enb_n
+ enb EN VSS VSS
+ sky130_fd_pr__nfet_01v8
+ w='1' l='0.15' nf='1' ad='int((nf+1)/2) * w/nf * 0.29' As='int((nf+2)/2) * w/nf * 0.29' pd='2*int((nf+1)/2) * (w/nf + 0.29)' ps='2*int((nf+2)/2) * (w/nf + 0.29)' nrd='0.29 / w' nrs='0.29 / w' sa='0' sb='0' sd='0' mult='1' m='1'

xm_ibias1_ref
+ vbp1 vbp1 VDD VDD
+ sky130_fd_pr__pfet_01v8
+ w='3' l='4' nf='1' ad='int((nf+1)/2) * w/nf * 0.29' As='int((nf+2)/2) * w/nf * 0.29' pd='2*int((nf+1)/2) * (w/nf + 0.29)' ps='2*int((nf+2)/2) * (w/nf + 0.29)' nrd='0.29 / w' nrs='0.29 / w' sa='0' sb='0' sd='0' mult='1' m='1'

xr_ibias1_ref
+ vbp1 vss_bias1 VSS
+ sky130_fd_pr__res_xhigh_po_0p35
+ l='38.94328833566177' mult='1' m='1'

xm_bias1_en
+ vss_bias1 EN VSS VSS
+ sky130_fd_pr__nfet_01v8
+ w='4' l='0.15' nf='1' ad='int((nf+1)/2) * w/nf * 0.29' As='int((nf+2)/2) * w/nf * 0.29' pd='2*int((nf+1)/2) * (w/nf + 0.29)' ps='2*int((nf+2)/2) * (w/nf + 0.29)' nrd='0.29 / w' nrs='0.29 / w' sa='0' sb='0' sd='0' mult='1' m='1'

xm_ibias1
+ ibias1 vbp1 VDD VDD
+ sky130_fd_pr__pfet_01v8
+ w='4' l='4' nf='1' ad='int((nf+1)/2) * w/nf * 0.29' As='int((nf+2)/2) * w/nf * 0.29' pd='2*int((nf+1)/2) * (w/nf + 0.29)' ps='2*int((nf+2)/2) * (w/nf + 0.29)' nrd='0.29 / w' nrs='0.29 / w' sa='0' sb='0' sd='0' mult='1' m='1'

xm_tail1_sw
+ tail1 enb ibias1 VDD
+ sky130_fd_pr__pfet_01v8
+ w='12' l='0.15' nf='1' ad='int((nf+1)/2) * w/nf * 0.29' As='int((nf+2)/2) * w/nf * 0.29' pd='2*int((nf+1)/2) * (w/nf + 0.29)' ps='2*int((nf+2)/2) * (w/nf + 0.29)' nrd='0.29 / w' nrs='0.29 / w' sa='0' sb='0' sd='0' mult='1' m='1'

xm_ibias1_off
+ vbp1 EN VDD VDD
+ sky130_fd_pr__pfet_01v8
+ w='2' l='0.15' nf='1' ad='int((nf+1)/2) * w/nf * 0.29' As='int((nf+2)/2) * w/nf * 0.29' pd='2*int((nf+1)/2) * (w/nf + 0.29)' ps='2*int((nf+2)/2) * (w/nf + 0.29)' nrd='0.29 / w' nrs='0.29 / w' sa='0' sb='0' sd='0' mult='1' m='1'

xm_ibias1_tail_off
+ ibias1 EN VDD VDD
+ sky130_fd_pr__pfet_01v8
+ w='2' l='0.15' nf='1' ad='int((nf+1)/2) * w/nf * 0.29' As='int((nf+2)/2) * w/nf * 0.29' pd='2*int((nf+1)/2) * (w/nf + 0.29)' ps='2*int((nf+2)/2) * (w/nf + 0.29)' nrd='0.29 / w' nrs='0.29 / w' sa='0' sb='0' sd='0' mult='1' m='1'

xm_tail1_off
+ tail1 EN VDD VDD
+ sky130_fd_pr__pfet_01v8
+ w='2' l='0.15' nf='1' ad='int((nf+1)/2) * w/nf * 0.29' As='int((nf+2)/2) * w/nf * 0.29' pd='2*int((nf+1)/2) * (w/nf + 0.29)' ps='2*int((nf+2)/2) * (w/nf + 0.29)' nrd='0.29 / w' nrs='0.29 / w' sa='0' sb='0' sd='0' mult='1' m='1'

xm_vinp_tg_n
+ vinp_int EN VINP VSS
+ sky130_fd_pr__nfet_01v8
+ w='4' l='0.15' nf='1' ad='int((nf+1)/2) * w/nf * 0.29' As='int((nf+2)/2) * w/nf * 0.29' pd='2*int((nf+1)/2) * (w/nf + 0.29)' ps='2*int((nf+2)/2) * (w/nf + 0.29)' nrd='0.29 / w' nrs='0.29 / w' sa='0' sb='0' sd='0' mult='1' m='1'

xm_vinp_tg_p
+ vinp_int enb VINP VDD
+ sky130_fd_pr__pfet_01v8
+ w='4' l='0.15' nf='1' ad='int((nf+1)/2) * w/nf * 0.29' As='int((nf+2)/2) * w/nf * 0.29' pd='2*int((nf+1)/2) * (w/nf + 0.29)' ps='2*int((nf+2)/2) * (w/nf + 0.29)' nrd='0.29 / w' nrs='0.29 / w' sa='0' sb='0' sd='0' mult='1' m='1'

xm_vinn_tg_n
+ vinn_int EN VINN VSS
+ sky130_fd_pr__nfet_01v8
+ w='4' l='0.15' nf='1' ad='int((nf+1)/2) * w/nf * 0.29' As='int((nf+2)/2) * w/nf * 0.29' pd='2*int((nf+1)/2) * (w/nf + 0.29)' ps='2*int((nf+2)/2) * (w/nf + 0.29)' nrd='0.29 / w' nrs='0.29 / w' sa='0' sb='0' sd='0' mult='1' m='1'

xm_vinn_tg_p
+ vinn_int enb VINN VDD
+ sky130_fd_pr__pfet_01v8
+ w='4' l='0.15' nf='1' ad='int((nf+1)/2) * w/nf * 0.29' As='int((nf+2)/2) * w/nf * 0.29' pd='2*int((nf+1)/2) * (w/nf + 0.29)' ps='2*int((nf+2)/2) * (w/nf + 0.29)' nrd='0.29 / w' nrs='0.29 / w' sa='0' sb='0' sd='0' mult='1' m='1'

xm_vinp_off
+ vinp_int EN VDD VDD
+ sky130_fd_pr__pfet_01v8
+ w='2' l='0.15' nf='1' ad='int((nf+1)/2) * w/nf * 0.29' As='int((nf+2)/2) * w/nf * 0.29' pd='2*int((nf+1)/2) * (w/nf + 0.29)' ps='2*int((nf+2)/2) * (w/nf + 0.29)' nrd='0.29 / w' nrs='0.29 / w' sa='0' sb='0' sd='0' mult='1' m='1'

xm_vinn_off
+ vinn_int EN VDD VDD
+ sky130_fd_pr__pfet_01v8
+ w='2' l='0.15' nf='1' ad='int((nf+1)/2) * w/nf * 0.29' As='int((nf+2)/2) * w/nf * 0.29' pd='2*int((nf+1)/2) * (w/nf + 0.29)' ps='2*int((nf+2)/2) * (w/nf + 0.29)' nrd='0.29 / w' nrs='0.29 / w' sa='0' sb='0' sd='0' mult='1' m='1'

xxin
+ vinp_int vinn_int vx vref tail1 VDD VSS
+ DiffpairP_7d3f4fa52beb1249cfa0798f031fdeeb_
* No parameters

xm_load_ref
+ vref vref VSS VSS
+ sky130_fd_pr__nfet_01v8
+ w='4' l='8' nf='1' ad='int((nf+1)/2) * w/nf * 0.29' As='int((nf+2)/2) * w/nf * 0.29' pd='2*int((nf+1)/2) * (w/nf + 0.29)' ps='2*int((nf+2)/2) * (w/nf + 0.29)' nrd='0.29 / w' nrs='0.29 / w' sa='0' sb='0' sd='0' mult='1' m='1'

xm_load_out
+ vx vref VSS VSS
+ sky130_fd_pr__nfet_01v8
+ w='4' l='8' nf='1' ad='int((nf+1)/2) * w/nf * 0.29' As='int((nf+2)/2) * w/nf * 0.29' pd='2*int((nf+1)/2) * (w/nf + 0.29)' ps='2*int((nf+2)/2) * (w/nf + 0.29)' nrd='0.29 / w' nrs='0.29 / w' sa='0' sb='0' sd='0' mult='1' m='1'

xm_ibias2_ref
+ ibias2 ibias2 VDD VDD
+ sky130_fd_pr__pfet_01v8
+ w='3' l='4' nf='1' ad='int((nf+1)/2) * w/nf * 0.29' As='int((nf+2)/2) * w/nf * 0.29' pd='2*int((nf+1)/2) * (w/nf + 0.29)' ps='2*int((nf+2)/2) * (w/nf + 0.29)' nrd='0.29 / w' nrs='0.29 / w' sa='0' sb='0' sd='0' mult='1' m='1'

rr_ibias2_ref
+ ibias2 vss_bias2
+ sky130_fd_pr__res_generic_po
+ w='0.35' l='237.23452327157705' m='1'

xm_bias2_en
+ vss_bias2 EN VSS VSS
+ sky130_fd_pr__nfet_01v8
+ w='4' l='0.15' nf='1' ad='int((nf+1)/2) * w/nf * 0.29' As='int((nf+2)/2) * w/nf * 0.29' pd='2*int((nf+1)/2) * (w/nf + 0.29)' ps='2*int((nf+2)/2) * (w/nf + 0.29)' nrd='0.29 / w' nrs='0.29 / w' sa='0' sb='0' sd='0' mult='1' m='1'

xm_ibias2_off
+ ibias2 EN VDD VDD
+ sky130_fd_pr__pfet_01v8
+ w='2' l='0.15' nf='1' ad='int((nf+1)/2) * w/nf * 0.29' As='int((nf+2)/2) * w/nf * 0.29' pd='2*int((nf+1)/2) * (w/nf + 0.29)' ps='2*int((nf+2)/2) * (w/nf + 0.29)' nrd='0.29 / w' nrs='0.29 / w' sa='0' sb='0' sd='0' mult='1' m='1'

xm_stage2_p
+ vdrv ibias2 VDD VDD
+ sky130_fd_pr__pfet_01v8
+ w='12' l='10' nf='1' ad='int((nf+1)/2) * w/nf * 0.29' As='int((nf+2)/2) * w/nf * 0.29' pd='2*int((nf+1)/2) * (w/nf + 0.29)' ps='2*int((nf+2)/2) * (w/nf + 0.29)' nrd='0.29 / w' nrs='0.29 / w' sa='0' sb='0' sd='0' mult='1' m='1'

xm_stage2_n
+ vdrv vx VSS VSS
+ sky130_fd_pr__nfet_01v8
+ w='20' l='6' nf='1' ad='int((nf+1)/2) * w/nf * 0.29' As='int((nf+2)/2) * w/nf * 0.29' pd='2*int((nf+1)/2) * (w/nf + 0.29)' ps='2*int((nf+2)/2) * (w/nf + 0.29)' nrd='0.29 / w' nrs='0.29 / w' sa='0' sb='0' sd='0' mult='1' m='1'

xm_stage2_off
+ vdrv enb VSS VSS
+ sky130_fd_pr__nfet_01v8
+ w='1' l='0.15' nf='1' ad='int((nf+1)/2) * w/nf * 0.29' As='int((nf+2)/2) * w/nf * 0.29' pd='2*int((nf+1)/2) * (w/nf + 0.29)' ps='2*int((nf+2)/2) * (w/nf + 0.29)' nrd='0.29 / w' nrs='0.29 / w' sa='0' sb='0' sd='0' mult='1' m='1'

rr_vdrv_out
+ vdrv VOUT
+ sky130_fd_pr__res_generic_m5
+ w='2' l='176.99115044247787' m='1'

xm_gp_sw_n
+ gp_link_src EN vdrv VSS
+ sky130_fd_pr__nfet_01v8
+ w='1' l='0.15' nf='1' ad='int((nf+1)/2) * w/nf * 0.29' As='int((nf+2)/2) * w/nf * 0.29' pd='2*int((nf+1)/2) * (w/nf + 0.29)' ps='2*int((nf+2)/2) * (w/nf + 0.29)' nrd='0.29 / w' nrs='0.29 / w' sa='0' sb='0' sd='0' mult='1' m='1'

xm_gp_sw_p
+ gp_link_src enb vdrv VDD
+ sky130_fd_pr__pfet_01v8
+ w='1' l='0.15' nf='1' ad='int((nf+1)/2) * w/nf * 0.29' As='int((nf+2)/2) * w/nf * 0.29' pd='2*int((nf+1)/2) * (w/nf + 0.29)' ps='2*int((nf+2)/2) * (w/nf + 0.29)' nrd='0.29 / w' nrs='0.29 / w' sa='0' sb='0' sd='0' mult='1' m='1'

rr_gp
+ gp_link_src gp
+ sky130_fd_pr__res_generic_po
+ w='0.35' l='790.7817442385901' m='1'

xm_gp_off
+ gp EN VDD VDD
+ sky130_fd_pr__pfet_01v8
+ w='2' l='0.15' nf='1' ad='int((nf+1)/2) * w/nf * 0.29' As='int((nf+2)/2) * w/nf * 0.29' pd='2*int((nf+1)/2) * (w/nf + 0.29)' ps='2*int((nf+2)/2) * (w/nf + 0.29)' nrd='0.29 / w' nrs='0.29 / w' sa='0' sb='0' sd='0' mult='1' m='1'

xm_out_p
+ VOUT gp VDD VDD
+ sky130_fd_pr__pfet_01v8
+ w='1.2' l='0.5' nf='1' ad='int((nf+1)/2) * w/nf * 0.29' As='int((nf+2)/2) * w/nf * 0.29' pd='2*int((nf+1)/2) * (w/nf + 0.29)' ps='2*int((nf+2)/2) * (w/nf + 0.29)' nrd='0.29 / w' nrs='0.29 / w' sa='0' sb='0' sd='0' mult='1' m='1'

xcc
+ vx vdrv
+ sky130_fd_pr__cap_mim_m3_1
+ w='10.488088481701515' l='10.488088481701515' mf='1'

.ENDS

.SUBCKT OpampAzTopV3Prod_af9ca0572e8cee9a521b7441d2a5f908_
+ VINP VINN VOUT EN PHI1 PHI1B PHI2 PHI2B PHI3 PHI3B VDD VSS
* No parameters

xxfront
+ VINP VINN VOUT vxp vxn PHI1 PHI1B PHI2 PHI2B PHI3 PHI3B VDD VSS
+ FrontendAzV3_95d94e55881d0f557dc14f96e68b57a7_
* No parameters

xxcore
+ vxp vxn VOUT EN VDD VSS
+ OpampCoreV3_c43733b6dd8b7d40d75df6a5d7623f30_
* No parameters

.ENDS

.SUBCKT Tb
+ VSS
* No parameters

vvvdd
+ vdd_sig VSS
+ DC 1.8
* No parameters

vven
+ en VSS
+ DC 1.8
* No parameters

vvvinp
+ vinp VSS
+ DC 0
* No parameters

rrfb
+ vout vinn
+ 1
* No parameters

vvphi1
+ phi1 VSS
+ PULSE (0 1.8 0 2E-8 2E-8 0.0000014000000000000001 0.000005)
* No parameters

vvphi1b
+ phi1b VSS
+ PULSE (1.8 0 0 2E-8 2E-8 0.0000014000000000000001 0.000005)
* No parameters

vvphi2
+ phi2 VSS
+ PULSE (0 1.8 0.0000019 2E-8 2E-8 7.000000000000001E-7 0.000005)
* No parameters

vvphi2b
+ phi2b VSS
+ PULSE (1.8 0 0.0000019 2E-8 2E-8 7.000000000000001E-7 0.000005)
* No parameters

vvphi3
+ phi3 VSS
+ PULSE (0 1.8 0.0000031 2E-8 2E-8 0.0000014000000000000001 0.000005)
* No parameters

vvphi3b
+ phi3b VSS
+ PULSE (1.8 0 0.0000031 2E-8 2E-8 0.0000014000000000000001 0.000005)
* No parameters

ccload
+ vout VSS
+ 1E-12
* No parameters

rrload
+ vout VSS
+ 1000000
* No parameters

xxdut
+ vinp vinn vout en phi1 phi1b phi2 phi2b phi3 phi3b vdd_sig VSS
+ OpampAzTopV3Prod_af9ca0572e8cee9a521b7441d2a5f908_
* No parameters

.ENDS

xtop 0 Tb // Top-Level DUT

.save time v(xtop.vout) v(xtop.phi3)
.temp 125.0
.lib "__SKY130_LIB_SPICE__" tt
.tran 1e-07 6e-05
