* Anonymous `circuit.Package`
* Generated by `vlsirtools.SpiceNetlister`
*

.SUBCKT DiffpairP_b7f551f6a5e9ff6a869c4cc40929350e_
+ INP INN OUTP OUTN TAIL VDD VSS
* No parameters

rshort_p
+ TAIL srcp
+ 0.001
* No parameters

rshort_n
+ TAIL srcn
+ 0.001
* No parameters

xmp
+ OUTP INP srcp VDD
+ sky130_fd_pr__pfet_01v8
+ w='14' l='3' nf='1' ad='int((nf+1)/2) * w/nf * 0.29' As='int((nf+2)/2) * w/nf * 0.29' pd='2*int((nf+1)/2) * (w/nf + 0.29)' ps='2*int((nf+2)/2) * (w/nf + 0.29)' nrd='0.29 / w' nrs='0.29 / w' sa='0' sb='0' sd='0' mult='1' m='1'

xmn
+ OUTN INN srcn VDD
+ sky130_fd_pr__pfet_01v8
+ w='14' l='3' nf='1' ad='int((nf+1)/2) * w/nf * 0.29' As='int((nf+2)/2) * w/nf * 0.29' pd='2*int((nf+1)/2) * (w/nf + 0.29)' ps='2*int((nf+2)/2) * (w/nf + 0.29)' nrd='0.29 / w' nrs='0.29 / w' sa='0' sb='0' sd='0' mult='1' m='1'

.ENDS

.SUBCKT OpampOtaV3_4ccc358b2967cc6d58234e092d8fc145_
+ VINP VINN VOUT VDD VSS
* No parameters

xm_ibias1_ref
+ vbp1 vbp1 VDD VDD
+ sky130_fd_pr__pfet_01v8
+ w='3' l='4' nf='1' ad='int((nf+1)/2) * w/nf * 0.29' As='int((nf+2)/2) * w/nf * 0.29' pd='2*int((nf+1)/2) * (w/nf + 0.29)' ps='2*int((nf+2)/2) * (w/nf + 0.29)' nrd='0.29 / w' nrs='0.29 / w' sa='0' sb='0' sd='0' mult='1' m='1'

xr_ibias1_ref
+ vbp1 vss_bias1 VSS
+ sky130_fd_pr__res_xhigh_po_0p35
+ l='38.94328833566177' mult='1' m='1'

xm_bias1_on
+ vss_bias1 VDD VSS VSS
+ sky130_fd_pr__nfet_01v8
+ w='4' l='0.15' nf='1' ad='int((nf+1)/2) * w/nf * 0.29' As='int((nf+2)/2) * w/nf * 0.29' pd='2*int((nf+1)/2) * (w/nf + 0.29)' ps='2*int((nf+2)/2) * (w/nf + 0.29)' nrd='0.29 / w' nrs='0.29 / w' sa='0' sb='0' sd='0' mult='1' m='1'

xm_ibias1
+ ibias1 vbp1 VDD VDD
+ sky130_fd_pr__pfet_01v8
+ w='4' l='4' nf='1' ad='int((nf+1)/2) * w/nf * 0.29' As='int((nf+2)/2) * w/nf * 0.29' pd='2*int((nf+1)/2) * (w/nf + 0.29)' ps='2*int((nf+2)/2) * (w/nf + 0.29)' nrd='0.29 / w' nrs='0.29 / w' sa='0' sb='0' sd='0' mult='1' m='1'

vvlink_tail1
+ ibias1 tail1
+ dc '0'
+ ac '0'
* No parameters

xxin
+ VINP VINN vx vref tail1 VDD VSS
+ DiffpairP_b7f551f6a5e9ff6a869c4cc40929350e_
* No parameters

xm_load_ref
+ vref vref VSS VSS
+ sky130_fd_pr__nfet_01v8
+ w='4' l='8' nf='1' ad='int((nf+1)/2) * w/nf * 0.29' As='int((nf+2)/2) * w/nf * 0.29' pd='2*int((nf+1)/2) * (w/nf + 0.29)' ps='2*int((nf+2)/2) * (w/nf + 0.29)' nrd='0.29 / w' nrs='0.29 / w' sa='0' sb='0' sd='0' mult='1' m='1'

xm_load_out
+ vx vref VSS VSS
+ sky130_fd_pr__nfet_01v8
+ w='4' l='8' nf='1' ad='int((nf+1)/2) * w/nf * 0.29' As='int((nf+2)/2) * w/nf * 0.29' pd='2*int((nf+1)/2) * (w/nf + 0.29)' ps='2*int((nf+2)/2) * (w/nf + 0.29)' nrd='0.29 / w' nrs='0.29 / w' sa='0' sb='0' sd='0' mult='1' m='1'

xm_ibias2_ref
+ ibias2 ibias2 VDD VDD
+ sky130_fd_pr__pfet_01v8
+ w='3' l='4' nf='1' ad='int((nf+1)/2) * w/nf * 0.29' As='int((nf+2)/2) * w/nf * 0.29' pd='2*int((nf+1)/2) * (w/nf + 0.29)' ps='2*int((nf+2)/2) * (w/nf + 0.29)' nrd='0.29 / w' nrs='0.29 / w' sa='0' sb='0' sd='0' mult='1' m='1'

xr_ibias2_ref
+ ibias2 vss_bias2 VSS
+ sky130_fd_pr__res_xhigh_po_0p35
+ l='85.6752343384559' mult='1' m='1'

xm_bias2_on
+ vss_bias2 VDD VSS VSS
+ sky130_fd_pr__nfet_01v8
+ w='4' l='0.15' nf='1' ad='int((nf+1)/2) * w/nf * 0.29' As='int((nf+2)/2) * w/nf * 0.29' pd='2*int((nf+1)/2) * (w/nf + 0.29)' ps='2*int((nf+2)/2) * (w/nf + 0.29)' nrd='0.29 / w' nrs='0.29 / w' sa='0' sb='0' sd='0' mult='1' m='1'

vvshift_stage2_gate
+ vg_stage2 vx
+ dc '0.18'
+ ac '0'
* No parameters

xm_stage2_p
+ vdrv ibias2 VDD VDD
+ sky130_fd_pr__pfet_01v8
+ w='12' l='12' nf='1' ad='int((nf+1)/2) * w/nf * 0.29' As='int((nf+2)/2) * w/nf * 0.29' pd='2*int((nf+1)/2) * (w/nf + 0.29)' ps='2*int((nf+2)/2) * (w/nf + 0.29)' nrd='0.29 / w' nrs='0.29 / w' sa='0' sb='0' sd='0' mult='1' m='1'

xm_stage2_n
+ vdrv vg_stage2 VSS VSS
+ sky130_fd_pr__nfet_01v8
+ w='24' l='6' nf='1' ad='int((nf+1)/2) * w/nf * 0.29' As='int((nf+2)/2) * w/nf * 0.29' pd='2*int((nf+1)/2) * (w/nf + 0.29)' ps='2*int((nf+2)/2) * (w/nf + 0.29)' nrd='0.29 / w' nrs='0.29 / w' sa='0' sb='0' sd='0' mult='1' m='1'

vvlink_vout
+ vdrv VOUT
+ dc '0'
+ ac '0'
* No parameters

xcc
+ vx vdrv
+ sky130_fd_pr__cap_mim_m3_1
+ w='36.74234614174767' l='36.74234614174767' mf='1'

.ENDS
