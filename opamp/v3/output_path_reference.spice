// `circuit.Package` `spice`
// Generated by `vlsirtools.SpectreNetlister`
//

subckt ReferenceOutputPathMethod2_4e771dfe78253f601cf16a3fc0c5cbef_
  + VDRV VOUT VDD VSS
  + // No parameters

  m_inv_p
  + // Ports:
  + ( vdrvb VDRV VDD VDD )
  +  sky130_fd_pr__pfet_01v8
  +  w=1 l=2 nf=1 ad=int((nf+1)/2) * w/nf * 0.29 As=int((nf+2)/2) * w/nf * 0.29 pd=2*int((nf+1)/2) * (w/nf + 0.29) ps=2*int((nf+2)/2) * (w/nf + 0.29) nrd=0.29 / w nrs=0.29 / w sa=0 sb=0 sd=0 mult=1 m=1

  m_inv_n
  + // Ports:
  + ( vdrvb VDRV VSS VSS )
  +  sky130_fd_pr__nfet_01v8
  +  w=0.5 l=2 nf=1 ad=int((nf+1)/2) * w/nf * 0.29 As=int((nf+2)/2) * w/nf * 0.29 pd=2*int((nf+1)/2) * (w/nf + 0.29) ps=2*int((nf+2)/2) * (w/nf + 0.29) nrd=0.29 / w nrs=0.29 / w sa=0 sb=0 sd=0 mult=1 m=1

  vprobe_bias_p
  + // Ports:
  + ( VDD vdd_bias_p )
  +  vsource
  +  dc=0 type=dc mag=0

  m_bias_p
  + // Ports:
  + ( vgp_q vgp_q vdd_bias_p VDD )
  +  sky130_fd_pr__pfet_01v8
  +  w=1.2 l=1 nf=1 ad=int((nf+1)/2) * w/nf * 0.29 As=int((nf+2)/2) * w/nf * 0.29 pd=2*int((nf+1)/2) * (w/nf + 0.29) ps=2*int((nf+2)/2) * (w/nf + 0.29) nrd=0.29 / w nrs=0.29 / w sa=0 sb=0 sd=0 mult=1 m=1

  r_bias
  + // Ports:
  + ( vgp_q vgn_q )
  +  sky130_fd_pr__res_generic_po
  +  w=0.35 l=94.89380930863081 m=1

  vprobe_bias_n
  + // Ports:
  + ( vss_bias_n VSS )
  +  vsource
  +  dc=0 type=dc mag=0

  m_bias_n
  + // Ports:
  + ( vgn_q vgn_q vss_bias_n VSS )
  +  sky130_fd_pr__nfet_01v8
  +  w=0.6 l=1 nf=1 ad=int((nf+1)/2) * w/nf * 0.29 As=int((nf+2)/2) * w/nf * 0.29 pd=2*int((nf+1)/2) * (w/nf + 0.29) ps=2*int((nf+2)/2) * (w/nf + 0.29) nrd=0.29 / w nrs=0.29 / w sa=0 sb=0 sd=0 mult=1 m=1

  r_keep_n
  + // Ports:
  + ( vgn_q VGN )
  +  sky130_fd_pr__res_generic_po
  +  w=0.35 l=47.446904654315404 m=1

  r_keep_p
  + // Ports:
  + ( vgp_q VGP )
  +  sky130_fd_pr__res_generic_po
  +  w=0.35 l=47.446904654315404 m=1

  r_sig_n
  + // Ports:
  + ( VDRV VGN VSS )
  +  sky130_fd_pr__res_xhigh_po_0p35
  +  l=18.69277840111765 mult=1 m=1

  r_sig_p
  + // Ports:
  + ( vdrvb VGP VSS )
  +  sky130_fd_pr__res_xhigh_po_0p35
  +  l=18.69277840111765 mult=1 m=1

  vprobe_outp
  + // Ports:
  + ( vout_p VOUT )
  +  vsource
  +  dc=0 type=dc mag=0

  vprobe_outn
  + // Ports:
  + ( vout_n VOUT )
  +  vsource
  +  dc=0 type=dc mag=0

  m_out_n
  + // Ports:
  + ( vout_n VGN VSS VSS )
  +  sky130_fd_pr__nfet_01v8
  +  w=1.2 l=0.5 nf=1 ad=int((nf+1)/2) * w/nf * 0.29 As=int((nf+2)/2) * w/nf * 0.29 pd=2*int((nf+1)/2) * (w/nf + 0.29) ps=2*int((nf+2)/2) * (w/nf + 0.29) nrd=0.29 / w nrs=0.29 / w sa=0 sb=0 sd=0 mult=1 m=1

  m_out_p
  + // Ports:
  + ( vout_p VGP VDD VDD )
  +  sky130_fd_pr__pfet_01v8
  +  w=2.4 l=0.5 nf=1 ad=int((nf+1)/2) * w/nf * 0.29 As=int((nf+2)/2) * w/nf * 0.29 pd=2*int((nf+1)/2) * (w/nf + 0.29) ps=2*int((nf+2)/2) * (w/nf + 0.29) nrd=0.29 / w nrs=0.29 / w sa=0 sb=0 sd=0 mult=1 m=1

ends
