* `ngspice` Sim Input for `opamp.v3.measure_core.Tb`
* Generated by `vlsirtools.CompatibleNgspiceNetlister`
*
* Anonymous `circuit.Package`
* Generated by `vlsirtools.CompatibleNgspiceNetlister`
*

.SUBCKT PBiasTailRef_ae4d847680dcfb722325c9856a9b7968_
+ VBP VDD VSS
* No parameters

xxpd
+ VBP VBP VDD VDD
+ sky130_fd_pr__pfet_01v8
+ w='2' l='2' nf='1' ad='int((nf+1)/2) * w/nf * 0.29' As='int((nf+2)/2) * w/nf * 0.29' pd='2*int((nf+1)/2) * (w/nf + 0.29)' ps='2*int((nf+2)/2) * (w/nf + 0.29)' nrd='0.29 / w' nrs='0.29 / w' sa='0' sb='0' sd='0' mult='1' m='1'

xxrb
+ VBP VSS VSS
+ sky130_fd_pr__res_xhigh_po_0p35
+ l='75' mult='1' m='1'

.ENDS

.SUBCKT NBiasCascodeRef_ae4d847680dcfb722325c9856a9b7968_
+ VBN VDD VSS
* No parameters

xxrb
+ VDD VBN VSS
+ sky130_fd_pr__res_xhigh_po_0p35
+ l='55' mult='1' m='1'

xxmnr
+ nrefb nrefb VSS VSS
+ sky130_fd_pr__nfet_01v8
+ w='4' l='8' nf='1' ad='int((nf+1)/2) * w/nf * 0.29' As='int((nf+2)/2) * w/nf * 0.29' pd='2*int((nf+1)/2) * (w/nf + 0.29)' ps='2*int((nf+2)/2) * (w/nf + 0.29)' nrd='0.29 / w' nrs='0.29 / w' sa='0' sb='0' sd='0' mult='1' m='1'

xxmcr
+ VBN VBN nrefb VSS
+ sky130_fd_pr__nfet_01v8
+ w='2' l='4' nf='1' ad='int((nf+1)/2) * w/nf * 0.29' As='int((nf+2)/2) * w/nf * 0.29' pd='2*int((nf+1)/2) * (w/nf + 0.29)' ps='2*int((nf+2)/2) * (w/nf + 0.29)' nrd='0.29 / w' nrs='0.29 / w' sa='0' sb='0' sd='0' mult='1' m='1'

.ENDS

.SUBCKT PBiasStage2Ref_ae4d847680dcfb722325c9856a9b7968_
+ VBP VDD VSS
* No parameters

xxpd
+ VBP VBP VDD VDD
+ sky130_fd_pr__pfet_01v8
+ w='2' l='2' nf='1' ad='int((nf+1)/2) * w/nf * 0.29' As='int((nf+2)/2) * w/nf * 0.29' pd='2*int((nf+1)/2) * (w/nf + 0.29)' ps='2*int((nf+2)/2) * (w/nf + 0.29)' nrd='0.29 / w' nrs='0.29 / w' sa='0' sb='0' sd='0' mult='1' m='1'

xxrb
+ VBP VSS VSS
+ sky130_fd_pr__res_xhigh_po_0p35
+ l='380' mult='1' m='1'

.ENDS

.SUBCKT PTailSource_ae4d847680dcfb722325c9856a9b7968_
+ OUT VBP VDD VSS
* No parameters

xxtail
+ OUT VBP VDD VDD
+ sky130_fd_pr__pfet_01v8
+ w='5' l='6' nf='1' ad='int((nf+1)/2) * w/nf * 0.29' As='int((nf+2)/2) * w/nf * 0.29' pd='2*int((nf+1)/2) * (w/nf + 0.29)' ps='2*int((nf+2)/2) * (w/nf + 0.29)' nrd='0.29 / w' nrs='0.29 / w' sa='0' sb='0' sd='0' mult='1' m='1'

.ENDS

.SUBCKT DiffpairP_b7f551f6a5e9ff6a869c4cc40929350e_
+ INP INN OUTP OUTN TAIL VDD VSS
* No parameters

rshort_p
+ TAIL srcp
+ 0.001
* No parameters

rshort_n
+ TAIL srcn
+ 0.001
* No parameters

xmp
+ OUTP INP srcp VDD
+ sky130_fd_pr__pfet_01v8
+ w='14' l='3' nf='1' ad='int((nf+1)/2) * w/nf * 0.29' As='int((nf+2)/2) * w/nf * 0.29' pd='2*int((nf+1)/2) * (w/nf + 0.29)' ps='2*int((nf+2)/2) * (w/nf + 0.29)' nrd='0.29 / w' nrs='0.29 / w' sa='0' sb='0' sd='0' mult='1' m='1'

xmn
+ OUTN INN srcn VDD
+ sky130_fd_pr__pfet_01v8
+ w='14' l='3' nf='1' ad='int((nf+1)/2) * w/nf * 0.29' As='int((nf+2)/2) * w/nf * 0.29' pd='2*int((nf+1)/2) * (w/nf + 0.29)' ps='2*int((nf+2)/2) * (w/nf + 0.29)' nrd='0.29 / w' nrs='0.29 / w' sa='0' sb='0' sd='0' mult='1' m='1'

.ENDS

.SUBCKT NMirrorLoadCascode_ae4d847680dcfb722325c9856a9b7968_
+ REFH OUTH VBN VDD VSS
* No parameters

xxmn_ref
+ nrefb nrefb VSS VSS
+ sky130_fd_pr__nfet_01v8
+ w='4' l='8' nf='1' ad='int((nf+1)/2) * w/nf * 0.29' As='int((nf+2)/2) * w/nf * 0.29' pd='2*int((nf+1)/2) * (w/nf + 0.29)' ps='2*int((nf+2)/2) * (w/nf + 0.29)' nrd='0.29 / w' nrs='0.29 / w' sa='0' sb='0' sd='0' mult='1' m='1'

xxmn_out
+ noutb nrefb VSS VSS
+ sky130_fd_pr__nfet_01v8
+ w='4' l='8' nf='1' ad='int((nf+1)/2) * w/nf * 0.29' As='int((nf+2)/2) * w/nf * 0.29' pd='2*int((nf+1)/2) * (w/nf + 0.29)' ps='2*int((nf+2)/2) * (w/nf + 0.29)' nrd='0.29 / w' nrs='0.29 / w' sa='0' sb='0' sd='0' mult='1' m='1'

xxmc_ref
+ REFH VBN nrefb VSS
+ sky130_fd_pr__nfet_01v8
+ w='2' l='4' nf='1' ad='int((nf+1)/2) * w/nf * 0.29' As='int((nf+2)/2) * w/nf * 0.29' pd='2*int((nf+1)/2) * (w/nf + 0.29)' ps='2*int((nf+2)/2) * (w/nf + 0.29)' nrd='0.29 / w' nrs='0.29 / w' sa='0' sb='0' sd='0' mult='1' m='1'

xxmc_out
+ OUTH VBN noutb VSS
+ sky130_fd_pr__nfet_01v8
+ w='2' l='4' nf='1' ad='int((nf+1)/2) * w/nf * 0.29' As='int((nf+2)/2) * w/nf * 0.29' pd='2*int((nf+1)/2) * (w/nf + 0.29)' ps='2*int((nf+2)/2) * (w/nf + 0.29)' nrd='0.29 / w' nrs='0.29 / w' sa='0' sb='0' sd='0' mult='1' m='1'

.ENDS

.SUBCKT Stage1PInputCascLoad_ae4d847680dcfb722325c9856a9b7968_
+ VINP VINN VX VTAIL VBN1 VDD VSS
* No parameters

xxdp
+ VINP VINN vref1 VX VTAIL VDD VSS
+ DiffpairP_b7f551f6a5e9ff6a869c4cc40929350e_
* No parameters

xxload
+ vref1 VX VBN1 VDD VSS
+ NMirrorLoadCascode_ae4d847680dcfb722325c9856a9b7968_
* No parameters

.ENDS

.SUBCKT Stage2NCommonSource_ae4d847680dcfb722325c9856a9b7968_
+ VX VOUT VBP2 VDD VSS
* No parameters

xxmp2
+ VOUT VBP2 VDD VDD
+ sky130_fd_pr__pfet_01v8
+ w='8' l='12' nf='1' ad='int((nf+1)/2) * w/nf * 0.29' As='int((nf+2)/2) * w/nf * 0.29' pd='2*int((nf+1)/2) * (w/nf + 0.29)' ps='2*int((nf+2)/2) * (w/nf + 0.29)' nrd='0.29 / w' nrs='0.29 / w' sa='0' sb='0' sd='0' mult='1' m='1'

xxmn2
+ VOUT VX VSS VSS
+ sky130_fd_pr__nfet_01v8
+ w='8' l='6' nf='1' ad='int((nf+1)/2) * w/nf * 0.29' As='int((nf+2)/2) * w/nf * 0.29' pd='2*int((nf+1)/2) * (w/nf + 0.29)' ps='2*int((nf+2)/2) * (w/nf + 0.29)' nrd='0.29 / w' nrs='0.29 / w' sa='0' sb='0' sd='0' mult='1' m='1'

.ENDS

.SUBCKT MillerRzCc_ae4d847680dcfb722325c9856a9b7968_
+ N1 N2 VSS
* No parameters

xxrz
+ N1 ncc VSS
+ sky130_fd_pr__res_xhigh_po_0p35
+ l='21' mult='1' m='1'

xxcc
+ ncc N2
+ sky130_fd_pr__cap_mim_m3_1
+ w='14.142' l='14.142' mf='1'

.ENDS

.SUBCKT OpampCoreV3_ae4d847680dcfb722325c9856a9b7968_
+ VINP VINN VOUT EN VDD VSS
* No parameters

xx_bp1
+ vbp1 VDD VSS
+ PBiasTailRef_ae4d847680dcfb722325c9856a9b7968_
* No parameters

xx_bn1
+ vbn1 VDD VSS
+ NBiasCascodeRef_ae4d847680dcfb722325c9856a9b7968_
* No parameters

xx_bp2
+ vbp2 VDD VSS
+ PBiasStage2Ref_ae4d847680dcfb722325c9856a9b7968_
* No parameters

xx_tail
+ vtail vbp1 VDD VSS
+ PTailSource_ae4d847680dcfb722325c9856a9b7968_
* No parameters

xx_stage1
+ VINP VINN vx vtail vbn1 VDD VSS
+ Stage1PInputCascLoad_ae4d847680dcfb722325c9856a9b7968_
* No parameters

xx_stage2
+ vx vout_int vbp2 VDD VSS
+ Stage2NCommonSource_ae4d847680dcfb722325c9856a9b7968_
* No parameters

xx_comp
+ vx vout_int VSS
+ MillerRzCc_ae4d847680dcfb722325c9856a9b7968_
* No parameters

vvvout_link
+ vout_int VOUT
+ DC 0
* No parameters

.ENDS

.SUBCKT Tb
+ VSS
* No parameters

vvvdd
+ vdd_sig VSS
+ DC 1.8
* No parameters

vven
+ en VSS
+ DC 1.8
* No parameters

vvvinp
+ vinp_sig VSS
+ DC 0.9
+ AC 1
* No parameters

vvvinn
+ vinn_sig VSS
+ DC 0.9
* No parameters

llfb
+ vout vinn_sig
+ 1000000000
* No parameters

ccload
+ vout VSS
+ 1E-12
* No parameters

rrload
+ vout VSS
+ 1000000000000
* No parameters

xxdut
+ vinp_sig vinn_sig vout en vdd_sig VSS
+ OpampCoreV3_ae4d847680dcfb722325c9856a9b7968_
* No parameters

.ENDS

xtop 0 Tb // Top-Level DUT

.save v(xtop.vout) v(xtop.vinn_sig)
.temp 27.0
.lib "__SKY130_LIB_SPICE__" tt
.ac dec 20 1.0 100000000.0
