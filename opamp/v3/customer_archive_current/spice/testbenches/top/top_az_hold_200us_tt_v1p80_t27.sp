* `ngspice` Sim Input for `opamp.v3.opamp_az_top.Tb`
* Generated by `vlsirtools.CompatibleNgspiceNetlister`
*
* Anonymous `circuit.Package`
* Generated by `vlsirtools.CompatibleNgspiceNetlister`
*

.SUBCKT TgSwitch_95c4d9ec09e05773a1cade7d2b1e31b9_
+ A B PHI PHIB VDD VSS
* No parameters

xsw_n
+ A PHI B VSS
+ sky130_fd_pr__nfet_01v8
+ w='1' l='0.15' nf='1' ad='int((nf+1)/2) * w/nf * 0.29' As='int((nf+2)/2) * w/nf * 0.29' pd='2*int((nf+1)/2) * (w/nf + 0.29)' ps='2*int((nf+2)/2) * (w/nf + 0.29)' nrd='0.29 / w' nrs='0.29 / w' sa='0' sb='0' sd='0' mult='1' m='1'

xsw_p
+ A PHIB B VDD
+ sky130_fd_pr__pfet_01v8
+ w='1.6' l='0.15' nf='1' ad='int((nf+1)/2) * w/nf * 0.29' As='int((nf+2)/2) * w/nf * 0.29' pd='2*int((nf+1)/2) * (w/nf + 0.29)' ps='2*int((nf+2)/2) * (w/nf + 0.29)' nrd='0.29 / w' nrs='0.29 / w' sa='0' sb='0' sd='0' mult='1' m='1'

.ENDS

.SUBCKT DiffpairP_b7f551f6a5e9ff6a869c4cc40929350e_
+ INP INN OUTP OUTN TAIL VDD VSS
* No parameters

rshort_p
+ TAIL srcp
+ 0.001
* No parameters

rshort_n
+ TAIL srcn
+ 0.001
* No parameters

xmp
+ OUTP INP srcp VDD
+ sky130_fd_pr__pfet_01v8
+ w='14' l='3' nf='1' ad='int((nf+1)/2) * w/nf * 0.29' As='int((nf+2)/2) * w/nf * 0.29' pd='2*int((nf+1)/2) * (w/nf + 0.29)' ps='2*int((nf+2)/2) * (w/nf + 0.29)' nrd='0.29 / w' nrs='0.29 / w' sa='0' sb='0' sd='0' mult='1' m='1'

xmn
+ OUTN INN srcn VDD
+ sky130_fd_pr__pfet_01v8
+ w='14' l='3' nf='1' ad='int((nf+1)/2) * w/nf * 0.29' As='int((nf+2)/2) * w/nf * 0.29' pd='2*int((nf+1)/2) * (w/nf + 0.29)' ps='2*int((nf+2)/2) * (w/nf + 0.29)' nrd='0.29 / w' nrs='0.29 / w' sa='0' sb='0' sd='0' mult='1' m='1'

.ENDS

.SUBCKT TgSwitch_6eee85f0190f17a07981a3b8f7f898e2_
+ A B PHI PHIB VDD VSS
* No parameters

xsw_n
+ A PHI B VSS
+ sky130_fd_pr__nfet_01v8
+ w='8' l='0.15' nf='1' ad='int((nf+1)/2) * w/nf * 0.29' As='int((nf+2)/2) * w/nf * 0.29' pd='2*int((nf+1)/2) * (w/nf + 0.29)' ps='2*int((nf+2)/2) * (w/nf + 0.29)' nrd='0.29 / w' nrs='0.29 / w' sa='0' sb='0' sd='0' mult='1' m='1'

xsw_p
+ A PHIB B VDD
+ sky130_fd_pr__pfet_01v8
+ w='12' l='0.15' nf='1' ad='int((nf+1)/2) * w/nf * 0.29' As='int((nf+2)/2) * w/nf * 0.29' pd='2*int((nf+1)/2) * (w/nf + 0.29)' ps='2*int((nf+2)/2) * (w/nf + 0.29)' nrd='0.29 / w' nrs='0.29 / w' sa='0' sb='0' sd='0' mult='1' m='1'

.ENDS

.SUBCKT OpampAzTopV3_e567ef64d47e5bcd6db747afc80c510e_
+ VINP VINN VOUT D_EN_OA D_AZ_OA D_INF_OA VDD VSS
* No parameters

xm_enb_p
+ enb D_EN_OA VDD VDD
+ sky130_fd_pr__pfet_01v8
+ w='2' l='0.15' nf='1' ad='int((nf+1)/2) * w/nf * 0.29' As='int((nf+2)/2) * w/nf * 0.29' pd='2*int((nf+1)/2) * (w/nf + 0.29)' ps='2*int((nf+2)/2) * (w/nf + 0.29)' nrd='0.29 / w' nrs='0.29 / w' sa='0' sb='0' sd='0' mult='1' m='1'

xm_enb_n
+ enb D_EN_OA VSS VSS
+ sky130_fd_pr__nfet_01v8
+ w='1' l='0.15' nf='1' ad='int((nf+1)/2) * w/nf * 0.29' As='int((nf+2)/2) * w/nf * 0.29' pd='2*int((nf+1)/2) * (w/nf + 0.29)' ps='2*int((nf+2)/2) * (w/nf + 0.29)' nrd='0.29 / w' nrs='0.29 / w' sa='0' sb='0' sd='0' mult='1' m='1'

xm_azb_p
+ azb D_AZ_OA VDD VDD
+ sky130_fd_pr__pfet_01v8
+ w='2' l='0.15' nf='1' ad='int((nf+1)/2) * w/nf * 0.29' As='int((nf+2)/2) * w/nf * 0.29' pd='2*int((nf+1)/2) * (w/nf + 0.29)' ps='2*int((nf+2)/2) * (w/nf + 0.29)' nrd='0.29 / w' nrs='0.29 / w' sa='0' sb='0' sd='0' mult='1' m='1'

xm_azb_n
+ azb D_AZ_OA VSS VSS
+ sky130_fd_pr__nfet_01v8
+ w='1' l='0.15' nf='1' ad='int((nf+1)/2) * w/nf * 0.29' As='int((nf+2)/2) * w/nf * 0.29' pd='2*int((nf+1)/2) * (w/nf + 0.29)' ps='2*int((nf+2)/2) * (w/nf + 0.29)' nrd='0.29 / w' nrs='0.29 / w' sa='0' sb='0' sd='0' mult='1' m='1'

xm_infb_p
+ infb D_INF_OA VDD VDD
+ sky130_fd_pr__pfet_01v8
+ w='2' l='0.15' nf='1' ad='int((nf+1)/2) * w/nf * 0.29' As='int((nf+2)/2) * w/nf * 0.29' pd='2*int((nf+1)/2) * (w/nf + 0.29)' ps='2*int((nf+2)/2) * (w/nf + 0.29)' nrd='0.29 / w' nrs='0.29 / w' sa='0' sb='0' sd='0' mult='1' m='1'

xm_infb_n
+ infb D_INF_OA VSS VSS
+ sky130_fd_pr__nfet_01v8
+ w='1' l='0.15' nf='1' ad='int((nf+1)/2) * w/nf * 0.29' As='int((nf+2)/2) * w/nf * 0.29' pd='2*int((nf+1)/2) * (w/nf + 0.29)' ps='2*int((nf+2)/2) * (w/nf + 0.29)' nrd='0.29 / w' nrs='0.29 / w' sa='0' sb='0' sd='0' mult='1' m='1'

xr_az_reset_delay
+ D_AZ_OA az_rc VSS
+ sky130_fd_pr__res_xhigh_po_0p35
+ l='15.577315334264709' mult='1' m='1'

xc_az_reset_delay
+ az_rc VSS
+ sky130_fd_pr__cap_mim_m3_1
+ w='15.811388300841896' l='15.811388300841896' mf='1'

xm_az_reset_raw_p
+ az_reset_raw az_rc VDD VDD
+ sky130_fd_pr__pfet_01v8
+ w='2' l='0.15' nf='1' ad='int((nf+1)/2) * w/nf * 0.29' As='int((nf+2)/2) * w/nf * 0.29' pd='2*int((nf+1)/2) * (w/nf + 0.29)' ps='2*int((nf+2)/2) * (w/nf + 0.29)' nrd='0.29 / w' nrs='0.29 / w' sa='0' sb='0' sd='0' mult='1' m='1'

xm_az_reset_raw_n
+ az_reset_raw az_rc VSS VSS
+ sky130_fd_pr__nfet_01v8
+ w='1' l='0.15' nf='1' ad='int((nf+1)/2) * w/nf * 0.29' As='int((nf+2)/2) * w/nf * 0.29' pd='2*int((nf+1)/2) * (w/nf + 0.29)' ps='2*int((nf+2)/2) * (w/nf + 0.29)' nrd='0.29 / w' nrs='0.29 / w' sa='0' sb='0' sd='0' mult='1' m='1'

xm_az_reset_rawb_p
+ az_reset_rawb az_reset_raw VDD VDD
+ sky130_fd_pr__pfet_01v8
+ w='2' l='0.15' nf='1' ad='int((nf+1)/2) * w/nf * 0.29' As='int((nf+2)/2) * w/nf * 0.29' pd='2*int((nf+1)/2) * (w/nf + 0.29)' ps='2*int((nf+2)/2) * (w/nf + 0.29)' nrd='0.29 / w' nrs='0.29 / w' sa='0' sb='0' sd='0' mult='1' m='1'

xm_az_reset_rawb_n
+ az_reset_rawb az_reset_raw VSS VSS
+ sky130_fd_pr__nfet_01v8
+ w='1' l='0.15' nf='1' ad='int((nf+1)/2) * w/nf * 0.29' As='int((nf+2)/2) * w/nf * 0.29' pd='2*int((nf+1)/2) * (w/nf + 0.29)' ps='2*int((nf+2)/2) * (w/nf + 0.29)' nrd='0.29 / w' nrs='0.29 / w' sa='0' sb='0' sd='0' mult='1' m='1'

xm_az_nand_reset_p0
+ az_nand_reset_b D_AZ_OA VDD VDD
+ sky130_fd_pr__pfet_01v8
+ w='2' l='0.15' nf='1' ad='int((nf+1)/2) * w/nf * 0.29' As='int((nf+2)/2) * w/nf * 0.29' pd='2*int((nf+1)/2) * (w/nf + 0.29)' ps='2*int((nf+2)/2) * (w/nf + 0.29)' nrd='0.29 / w' nrs='0.29 / w' sa='0' sb='0' sd='0' mult='1' m='1'

xm_az_nand_reset_p1
+ az_nand_reset_b az_reset_raw VDD VDD
+ sky130_fd_pr__pfet_01v8
+ w='2' l='0.15' nf='1' ad='int((nf+1)/2) * w/nf * 0.29' As='int((nf+2)/2) * w/nf * 0.29' pd='2*int((nf+1)/2) * (w/nf + 0.29)' ps='2*int((nf+2)/2) * (w/nf + 0.29)' nrd='0.29 / w' nrs='0.29 / w' sa='0' sb='0' sd='0' mult='1' m='1'

xm_az_nand_reset_n0
+ az_nand_reset_b D_AZ_OA az_nand_reset_mid VSS
+ sky130_fd_pr__nfet_01v8
+ w='1' l='0.15' nf='1' ad='int((nf+1)/2) * w/nf * 0.29' As='int((nf+2)/2) * w/nf * 0.29' pd='2*int((nf+1)/2) * (w/nf + 0.29)' ps='2*int((nf+2)/2) * (w/nf + 0.29)' nrd='0.29 / w' nrs='0.29 / w' sa='0' sb='0' sd='0' mult='1' m='1'

xm_az_nand_reset_n1
+ az_nand_reset_mid az_reset_raw VSS VSS
+ sky130_fd_pr__nfet_01v8
+ w='1' l='0.15' nf='1' ad='int((nf+1)/2) * w/nf * 0.29' As='int((nf+2)/2) * w/nf * 0.29' pd='2*int((nf+1)/2) * (w/nf + 0.29)' ps='2*int((nf+2)/2) * (w/nf + 0.29)' nrd='0.29 / w' nrs='0.29 / w' sa='0' sb='0' sd='0' mult='1' m='1'

xm_az_reset_p
+ az_reset az_nand_reset_b VDD VDD
+ sky130_fd_pr__pfet_01v8
+ w='2' l='0.15' nf='1' ad='int((nf+1)/2) * w/nf * 0.29' As='int((nf+2)/2) * w/nf * 0.29' pd='2*int((nf+1)/2) * (w/nf + 0.29)' ps='2*int((nf+2)/2) * (w/nf + 0.29)' nrd='0.29 / w' nrs='0.29 / w' sa='0' sb='0' sd='0' mult='1' m='1'

xm_az_reset_n
+ az_reset az_nand_reset_b VSS VSS
+ sky130_fd_pr__nfet_01v8
+ w='1' l='0.15' nf='1' ad='int((nf+1)/2) * w/nf * 0.29' As='int((nf+2)/2) * w/nf * 0.29' pd='2*int((nf+1)/2) * (w/nf + 0.29)' ps='2*int((nf+2)/2) * (w/nf + 0.29)' nrd='0.29 / w' nrs='0.29 / w' sa='0' sb='0' sd='0' mult='1' m='1'

xm_az_reset_b_p
+ az_reset_b az_reset VDD VDD
+ sky130_fd_pr__pfet_01v8
+ w='2' l='0.15' nf='1' ad='int((nf+1)/2) * w/nf * 0.29' As='int((nf+2)/2) * w/nf * 0.29' pd='2*int((nf+1)/2) * (w/nf + 0.29)' ps='2*int((nf+2)/2) * (w/nf + 0.29)' nrd='0.29 / w' nrs='0.29 / w' sa='0' sb='0' sd='0' mult='1' m='1'

xm_az_reset_b_n
+ az_reset_b az_reset VSS VSS
+ sky130_fd_pr__nfet_01v8
+ w='1' l='0.15' nf='1' ad='int((nf+1)/2) * w/nf * 0.29' As='int((nf+2)/2) * w/nf * 0.29' pd='2*int((nf+1)/2) * (w/nf + 0.29)' ps='2*int((nf+2)/2) * (w/nf + 0.29)' nrd='0.29 / w' nrs='0.29 / w' sa='0' sb='0' sd='0' mult='1' m='1'

xm_az_nand_null_p0
+ az_nand_null_b D_AZ_OA VDD VDD
+ sky130_fd_pr__pfet_01v8
+ w='2' l='0.15' nf='1' ad='int((nf+1)/2) * w/nf * 0.29' As='int((nf+2)/2) * w/nf * 0.29' pd='2*int((nf+1)/2) * (w/nf + 0.29)' ps='2*int((nf+2)/2) * (w/nf + 0.29)' nrd='0.29 / w' nrs='0.29 / w' sa='0' sb='0' sd='0' mult='1' m='1'

xm_az_nand_null_p1
+ az_nand_null_b az_reset_rawb VDD VDD
+ sky130_fd_pr__pfet_01v8
+ w='2' l='0.15' nf='1' ad='int((nf+1)/2) * w/nf * 0.29' As='int((nf+2)/2) * w/nf * 0.29' pd='2*int((nf+1)/2) * (w/nf + 0.29)' ps='2*int((nf+2)/2) * (w/nf + 0.29)' nrd='0.29 / w' nrs='0.29 / w' sa='0' sb='0' sd='0' mult='1' m='1'

xm_az_nand_null_n0
+ az_nand_null_b D_AZ_OA az_nand_null_mid VSS
+ sky130_fd_pr__nfet_01v8
+ w='1' l='0.15' nf='1' ad='int((nf+1)/2) * w/nf * 0.29' As='int((nf+2)/2) * w/nf * 0.29' pd='2*int((nf+1)/2) * (w/nf + 0.29)' ps='2*int((nf+2)/2) * (w/nf + 0.29)' nrd='0.29 / w' nrs='0.29 / w' sa='0' sb='0' sd='0' mult='1' m='1'

xm_az_nand_null_n1
+ az_nand_null_mid az_reset_rawb VSS VSS
+ sky130_fd_pr__nfet_01v8
+ w='1' l='0.15' nf='1' ad='int((nf+1)/2) * w/nf * 0.29' As='int((nf+2)/2) * w/nf * 0.29' pd='2*int((nf+1)/2) * (w/nf + 0.29)' ps='2*int((nf+2)/2) * (w/nf + 0.29)' nrd='0.29 / w' nrs='0.29 / w' sa='0' sb='0' sd='0' mult='1' m='1'

xm_az_null_p
+ az_null az_nand_null_b VDD VDD
+ sky130_fd_pr__pfet_01v8
+ w='2' l='0.15' nf='1' ad='int((nf+1)/2) * w/nf * 0.29' As='int((nf+2)/2) * w/nf * 0.29' pd='2*int((nf+1)/2) * (w/nf + 0.29)' ps='2*int((nf+2)/2) * (w/nf + 0.29)' nrd='0.29 / w' nrs='0.29 / w' sa='0' sb='0' sd='0' mult='1' m='1'

xm_az_null_n
+ az_null az_nand_null_b VSS VSS
+ sky130_fd_pr__nfet_01v8
+ w='1' l='0.15' nf='1' ad='int((nf+1)/2) * w/nf * 0.29' As='int((nf+2)/2) * w/nf * 0.29' pd='2*int((nf+1)/2) * (w/nf + 0.29)' ps='2*int((nf+2)/2) * (w/nf + 0.29)' nrd='0.29 / w' nrs='0.29 / w' sa='0' sb='0' sd='0' mult='1' m='1'

xm_az_null_b_p
+ az_null_b az_null VDD VDD
+ sky130_fd_pr__pfet_01v8
+ w='2' l='0.15' nf='1' ad='int((nf+1)/2) * w/nf * 0.29' As='int((nf+2)/2) * w/nf * 0.29' pd='2*int((nf+1)/2) * (w/nf + 0.29)' ps='2*int((nf+2)/2) * (w/nf + 0.29)' nrd='0.29 / w' nrs='0.29 / w' sa='0' sb='0' sd='0' mult='1' m='1'

xm_az_null_b_n
+ az_null_b az_null VSS VSS
+ sky130_fd_pr__nfet_01v8
+ w='1' l='0.15' nf='1' ad='int((nf+1)/2) * w/nf * 0.29' As='int((nf+2)/2) * w/nf * 0.29' pd='2*int((nf+1)/2) * (w/nf + 0.29)' ps='2*int((nf+2)/2) * (w/nf + 0.29)' nrd='0.29 / w' nrs='0.29 / w' sa='0' sb='0' sd='0' mult='1' m='1'

vvvcm_az
+ vcm_az VSS
+ DC 0.9
* No parameters

xr_vdrv_ref_top
+ VDD vdrv_qref VSS
+ sky130_fd_pr__res_xhigh_po_0p35
+ l='37.3855568022353' mult='1' m='1'

xr_vdrv_ref_bot
+ vdrv_qref VSS VSS
+ sky130_fd_pr__res_xhigh_po_0p35
+ l='15.577315334264709' mult='1' m='1'

xxsw_inp_ext
+ VINP vinp_core D_INF_OA infb VDD VSS
+ TgSwitch_95c4d9ec09e05773a1cade7d2b1e31b9_
* No parameters

xxsw_inn_ext
+ VINN vinn_core D_INF_OA infb VDD VSS
+ TgSwitch_95c4d9ec09e05773a1cade7d2b1e31b9_
* No parameters

xxsw_inp_az
+ vcm_az vinp_core D_AZ_OA azb VDD VSS
+ TgSwitch_95c4d9ec09e05773a1cade7d2b1e31b9_
* No parameters

xxsw_inn_az
+ vcm_az vinn_core D_AZ_OA azb VDD VSS
+ TgSwitch_95c4d9ec09e05773a1cade7d2b1e31b9_
* No parameters

xr_vinp_bleed
+ vinp_core vcm_az VSS
+ sky130_fd_pr__res_xhigh_po_0p35
+ l='7788.657667132355' mult='1' m='1'

xr_vinn_bleed
+ vinn_core vcm_az VSS
+ sky130_fd_pr__res_xhigh_po_0p35
+ l='7788.657667132355' mult='1' m='1'

xxsw_trim_reset_p
+ vcm_az vtrp az_reset az_reset_b VDD VSS
+ TgSwitch_95c4d9ec09e05773a1cade7d2b1e31b9_
* No parameters

xxsw_trim_reset_n
+ vcm_az vtrn az_reset az_reset_b VDD VSS
+ TgSwitch_95c4d9ec09e05773a1cade7d2b1e31b9_
* No parameters

xxsw_servo_sense
+ vdrv vsense_az az_null az_null_b VDD VSS
+ TgSwitch_95c4d9ec09e05773a1cade7d2b1e31b9_
* No parameters

xxsw_servo_target
+ vdrv_qref vtarget_az az_null az_null_b VDD VSS
+ TgSwitch_95c4d9ec09e05773a1cade7d2b1e31b9_
* No parameters

xxsw_servo_drive_p
+ vservo_p vtrp az_null az_null_b VDD VSS
+ TgSwitch_95c4d9ec09e05773a1cade7d2b1e31b9_
* No parameters

xxsw_servo_drive_n
+ vservo_n vtrn az_null az_null_b VDD VSS
+ TgSwitch_95c4d9ec09e05773a1cade7d2b1e31b9_
* No parameters

xr_vsense_bleed
+ vsense_az vcm_az VSS
+ sky130_fd_pr__res_xhigh_po_0p35
+ l='15577.31533426471' mult='1' m='1'

xr_vtarget_bleed
+ vtarget_az vcm_az VSS
+ sky130_fd_pr__res_xhigh_po_0p35
+ l='15577.31533426471' mult='1' m='1'

xr_vservo_p_bleed
+ vservo_p vcm_az VSS
+ sky130_fd_pr__res_xhigh_po_0p35
+ l='1557731.5334264708' mult='1' m='1'

xr_vservo_n_bleed
+ vservo_n vcm_az VSS
+ sky130_fd_pr__res_xhigh_po_0p35
+ l='1557731.5334264708' mult='1' m='1'

ggm_servo_p
+ vservo_p vcm_az vsense_az vtarget_az
+ 0.000005
* No parameters

ggm_servo_n
+ vcm_az vservo_n vsense_az vtarget_az
+ 0.000005
* No parameters

xcaz_n
+ vtrn vcm_az
+ sky130_fd_pr__cap_mim_m3_1
+ w='44.72135954999579' l='44.72135954999579' mf='1'

xcaz_p
+ vtrp vcm_az
+ sky130_fd_pr__cap_mim_m3_1
+ w='44.72135954999579' l='44.72135954999579' mf='1'

xr_vtrn_bleed
+ vtrn vcm_az VSS
+ sky130_fd_pr__res_xhigh_po_0p35
+ l='1557731.5334264708' mult='1' m='1'

xr_vtrp_bleed
+ vtrp vcm_az VSS
+ sky130_fd_pr__res_xhigh_po_0p35
+ l='1557731.5334264708' mult='1' m='1'

xm_ibias1_ref
+ vbp1 vbp1 VDD VDD
+ sky130_fd_pr__pfet_01v8
+ w='2' l='2' nf='1' ad='int((nf+1)/2) * w/nf * 0.29' As='int((nf+2)/2) * w/nf * 0.29' pd='2*int((nf+1)/2) * (w/nf + 0.29)' ps='2*int((nf+2)/2) * (w/nf + 0.29)' nrd='0.29 / w' nrs='0.29 / w' sa='0' sb='0' sd='0' mult='1' m='1'

xr_ibias1_ref
+ vbp1 vss_bias1 VSS
+ sky130_fd_pr__res_xhigh_po_0p35
+ l='74.7711136044706' mult='1' m='1'

xm_bias1_en
+ vss_bias1 D_EN_OA VSS VSS
+ sky130_fd_pr__nfet_01v8
+ w='4' l='0.15' nf='1' ad='int((nf+1)/2) * w/nf * 0.29' As='int((nf+2)/2) * w/nf * 0.29' pd='2*int((nf+1)/2) * (w/nf + 0.29)' ps='2*int((nf+2)/2) * (w/nf + 0.29)' nrd='0.29 / w' nrs='0.29 / w' sa='0' sb='0' sd='0' mult='1' m='1'

xm_ibias1
+ ibias1 vbp1 VDD VDD
+ sky130_fd_pr__pfet_01v8
+ w='5' l='6' nf='1' ad='int((nf+1)/2) * w/nf * 0.29' As='int((nf+2)/2) * w/nf * 0.29' pd='2*int((nf+1)/2) * (w/nf + 0.29)' ps='2*int((nf+2)/2) * (w/nf + 0.29)' nrd='0.29 / w' nrs='0.29 / w' sa='0' sb='0' sd='0' mult='1' m='1'

xm_tail1_sw
+ tail1 enb ibias1 VDD
+ sky130_fd_pr__pfet_01v8
+ w='12' l='0.15' nf='1' ad='int((nf+1)/2) * w/nf * 0.29' As='int((nf+2)/2) * w/nf * 0.29' pd='2*int((nf+1)/2) * (w/nf + 0.29)' ps='2*int((nf+2)/2) * (w/nf + 0.29)' nrd='0.29 / w' nrs='0.29 / w' sa='0' sb='0' sd='0' mult='1' m='1'

xm_ibias1_off
+ vbp1 D_EN_OA VDD VDD
+ sky130_fd_pr__pfet_01v8
+ w='2' l='0.15' nf='1' ad='int((nf+1)/2) * w/nf * 0.29' As='int((nf+2)/2) * w/nf * 0.29' pd='2*int((nf+1)/2) * (w/nf + 0.29)' ps='2*int((nf+2)/2) * (w/nf + 0.29)' nrd='0.29 / w' nrs='0.29 / w' sa='0' sb='0' sd='0' mult='1' m='1'

xm_ibias1_tail_off
+ ibias1 D_EN_OA VDD VDD
+ sky130_fd_pr__pfet_01v8
+ w='2' l='0.15' nf='1' ad='int((nf+1)/2) * w/nf * 0.29' As='int((nf+2)/2) * w/nf * 0.29' pd='2*int((nf+1)/2) * (w/nf + 0.29)' ps='2*int((nf+2)/2) * (w/nf + 0.29)' nrd='0.29 / w' nrs='0.29 / w' sa='0' sb='0' sd='0' mult='1' m='1'

xxin_main
+ vinp_core vinn_core vx vref tail1 VDD VSS
+ DiffpairP_b7f551f6a5e9ff6a869c4cc40929350e_
* No parameters

xr_trim_inp
+ vtrp vinp_core VSS
+ sky130_fd_pr__res_xhigh_po_0p35
+ l='3115.4630668529417' mult='1' m='1'

xr_trim_inn
+ vtrn vinn_core VSS
+ sky130_fd_pr__res_xhigh_po_0p35
+ l='3115.4630668529417' mult='1' m='1'

xm_load_ref
+ vref vref VSS VSS
+ sky130_fd_pr__nfet_01v8
+ w='4' l='8' nf='1' ad='int((nf+1)/2) * w/nf * 0.29' As='int((nf+2)/2) * w/nf * 0.29' pd='2*int((nf+1)/2) * (w/nf + 0.29)' ps='2*int((nf+2)/2) * (w/nf + 0.29)' nrd='0.29 / w' nrs='0.29 / w' sa='0' sb='0' sd='0' mult='1' m='1'

xm_load_out
+ vx vref VSS VSS
+ sky130_fd_pr__nfet_01v8
+ w='4' l='8' nf='1' ad='int((nf+1)/2) * w/nf * 0.29' As='int((nf+2)/2) * w/nf * 0.29' pd='2*int((nf+1)/2) * (w/nf + 0.29)' ps='2*int((nf+2)/2) * (w/nf + 0.29)' nrd='0.29 / w' nrs='0.29 / w' sa='0' sb='0' sd='0' mult='1' m='1'

xm_ibias2_ref
+ ibias2 ibias2 VDD VDD
+ sky130_fd_pr__pfet_01v8
+ w='2' l='2' nf='1' ad='int((nf+1)/2) * w/nf * 0.29' As='int((nf+2)/2) * w/nf * 0.29' pd='2*int((nf+1)/2) * (w/nf + 0.29)' ps='2*int((nf+2)/2) * (w/nf + 0.29)' nrd='0.29 / w' nrs='0.29 / w' sa='0' sb='0' sd='0' mult='1' m='1'

xr_ibias2_ref
+ ibias2 vss_bias2 VSS
+ sky130_fd_pr__res_xhigh_po_0p35
+ l='119.94532807383825' mult='1' m='1'

xm_bias2_en
+ vss_bias2 D_EN_OA VSS VSS
+ sky130_fd_pr__nfet_01v8
+ w='4' l='0.15' nf='1' ad='int((nf+1)/2) * w/nf * 0.29' As='int((nf+2)/2) * w/nf * 0.29' pd='2*int((nf+1)/2) * (w/nf + 0.29)' ps='2*int((nf+2)/2) * (w/nf + 0.29)' nrd='0.29 / w' nrs='0.29 / w' sa='0' sb='0' sd='0' mult='1' m='1'

xm_ibias2_off
+ ibias2 D_EN_OA VDD VDD
+ sky130_fd_pr__pfet_01v8
+ w='2' l='0.15' nf='1' ad='int((nf+1)/2) * w/nf * 0.29' As='int((nf+2)/2) * w/nf * 0.29' pd='2*int((nf+1)/2) * (w/nf + 0.29)' ps='2*int((nf+2)/2) * (w/nf + 0.29)' nrd='0.29 / w' nrs='0.29 / w' sa='0' sb='0' sd='0' mult='1' m='1'

xm_stage2_p
+ vdrv ibias2 VDD VDD
+ sky130_fd_pr__pfet_01v8
+ w='15' l='12' nf='1' ad='int((nf+1)/2) * w/nf * 0.29' As='int((nf+2)/2) * w/nf * 0.29' pd='2*int((nf+1)/2) * (w/nf + 0.29)' ps='2*int((nf+2)/2) * (w/nf + 0.29)' nrd='0.29 / w' nrs='0.29 / w' sa='0' sb='0' sd='0' mult='1' m='1'

xm_stage2_n
+ vdrv vx VSS VSS
+ sky130_fd_pr__nfet_01v8
+ w='8' l='12' nf='1' ad='int((nf+1)/2) * w/nf * 0.29' As='int((nf+2)/2) * w/nf * 0.29' pd='2*int((nf+1)/2) * (w/nf + 0.29)' ps='2*int((nf+2)/2) * (w/nf + 0.29)' nrd='0.29 / w' nrs='0.29 / w' sa='0' sb='0' sd='0' mult='1' m='1'

xm_stage2_off
+ vdrv enb VSS VSS
+ sky130_fd_pr__nfet_01v8
+ w='1' l='0.15' nf='1' ad='int((nf+1)/2) * w/nf * 0.29' As='int((nf+2)/2) * w/nf * 0.29' pd='2*int((nf+1)/2) * (w/nf + 0.29)' ps='2*int((nf+2)/2) * (w/nf + 0.29)' nrd='0.29 / w' nrs='0.29 / w' sa='0' sb='0' sd='0' mult='1' m='1'

xxsw_vout
+ vdrv VOUT D_INF_OA infb VDD VSS
+ TgSwitch_6eee85f0190f17a07981a3b8f7f898e2_
* No parameters

xcc
+ vx vdrv
+ sky130_fd_pr__cap_mim_m3_1
+ w='14.142135623730951' l='14.142135623730951' mf='1'

.ENDS

.SUBCKT Tb
+ VSS
* No parameters

vvvdd
+ vdd VSS
+ DC 1.8
* No parameters

vvden
+ den VSS
+ DC 1.8
* No parameters

vvdaz
+ daz VSS
+ PULSE (1.8 0 0.00001 2E-8 2E-8 0.000272 0.000544)
* No parameters

vvdinf
+ dinf VSS
+ PULSE (0 1.8 0.000012 2E-8 2E-8 0.00026 0.000544)
* No parameters

vvvin
+ vinp VSS
+ DC 0.9
* No parameters

rrfb
+ vout vinn
+ 1
* No parameters

ccload
+ vout VSS
+ 1E-12
* No parameters

rrload
+ vout VSS
+ 1000000
* No parameters

xxdut
+ vinp vinn vout den daz dinf vdd VSS
+ OpampAzTopV3_e567ef64d47e5bcd6db747afc80c510e_
* No parameters

.ENDS

xtop 0 Tb // Top-Level DUT

.save time v(xtop.vout) v(xtop.xdut.vtrp) v(xtop.xdut.vtrn) v(xtop.xdut.vdrv) v(xtop.daz) v(xtop.dinf)
.lib "__SKY130_LIB_SPICE__" tt
.tran 2e-07 0.000272
