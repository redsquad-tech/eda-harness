* `ngspice` Sim Input for `__main__.MirrorTb`
* Generated by `vlsirtools.NgspiceNetlister`
*
* Anonymous `circuit.Package`
* Generated by `vlsirtools.NgspiceNetlister`
*

.SUBCKT 15_nf_4_
+ ibias iout vss
* No parameters

xmref
+ ibias ibias vss vss
+ sky130_fd_pr__nfet_01v8
+ w='2' l='0.15' nf='4' ad='int((nf+1)/2) * w/nf * 0.29' As='int((nf+2)/2) * w/nf * 0.29' pd='2*int((nf+1)/2) * (w/nf + 0.29)' ps='2*int((nf+2)/2) * (w/nf + 0.29)' nrd='0.29 / w' nrs='0.29 / w' sa='0' sb='0' sd='0' mult='1' m='1'

xmout
+ iout ibias vss vss
+ sky130_fd_pr__nfet_01v8
+ w='2' l='0.15' nf='4' ad='int((nf+1)/2) * w/nf * 0.29' As='int((nf+2)/2) * w/nf * 0.29' pd='2*int((nf+1)/2) * (w/nf + 0.29)' ps='2*int((nf+2)/2) * (w/nf + 0.29)' nrd='0.29 / w' nrs='0.29 / w' sa='0' sb='0' sd='0' mult='1' m='1'

.ENDS

.SUBCKT MirrorTb
+ gnd
* No parameters

xxdut
+ ibias iout gnd
+ 15_nf_4_
* No parameters

iiref
+ ibias gnd
+ 0.00001
* No parameters

vvoutsrc
+ iout gnd
+ dc '1.8'
+ ac '0'
* No parameters

.ENDS

xtop 0 MirrorTb // Top-Level DUT

.option reltol = 0.00001

.lib "/mnt/storage/work/polin-agent/pdks/volare/sky130/versions/0fe599b2afb6708d281543108caf8310912f54af/sky130A/libs.tech/ngspice/sky130.lib.spice" tt
.op
