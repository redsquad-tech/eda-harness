// Anonymous `circuit.Package`
// Generated by `vlsirtools.SpectreNetlister`
//

subckt 15_nf_4_
  + ibias iout vss
  + // No parameters

  mref
  + // Ports:
  + ( ibias ibias vss vss )
  +  sky130_fd_pr__nfet_01v8
  +  w=2 l=0.15 nf=4 ad=int((nf+1)/2) * w/nf * 0.29 As=int((nf+2)/2) * w/nf * 0.29 pd=2*int((nf+1)/2) * (w/nf + 0.29) ps=2*int((nf+2)/2) * (w/nf + 0.29) nrd=0.29 / w nrs=0.29 / w sa=0 sb=0 sd=0 mult=1 m=1

  mout
  + // Ports:
  + ( iout ibias vss vss )
  +  sky130_fd_pr__nfet_01v8
  +  w=2 l=0.15 nf=4 ad=int((nf+1)/2) * w/nf * 0.29 As=int((nf+2)/2) * w/nf * 0.29 pd=2*int((nf+1)/2) * (w/nf + 0.29) ps=2*int((nf+2)/2) * (w/nf + 0.29) nrd=0.29 / w nrs=0.29 / w sa=0 sb=0 sd=0 mult=1 m=1

ends

subckt MirrorTb
  + gnd
  + // No parameters

  xdut
  + // Ports:
  + ( ibias iout gnd )
  +  15_nf_4_
  + // No parameters

  iref
  + // Ports:
  + ( ibias gnd )
  +  isource
  +  dc=10u

  voutsrc
  + // Ports:
  + ( iout gnd )
  +  vsource
  +  dc=0.9 type=dc mag=0

ends

.dc vvoutsrc 0 1.8 0.01
.save i(vvoutsrc) v(iout) v(ibias)
.end
